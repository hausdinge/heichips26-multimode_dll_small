* NGSPICE file created from heichips26_multimode_dll_small.ext - technology: ihp-sg13cmos5l

* Black-box entry subcircuit for sg13cmos5l_nor3_1 abstract view
.subckt sg13cmos5l_nor3_1 Y A B C VDD VSS
.ends

* Black-box entry subcircuit for sg13cmos5l_buf_8 abstract view
.subckt sg13cmos5l_buf_8 X A VDD VSS
.ends

* Black-box entry subcircuit for sg13cmos5l_o21ai_1 abstract view
.subckt sg13cmos5l_o21ai_1 Y A1 A2 B1 VDD VSS
.ends

* Black-box entry subcircuit for sg13cmos5l_a221oi_1 abstract view
.subckt sg13cmos5l_a221oi_1 Y A1 A2 B1 B2 C1 VDD VSS
.ends

* Black-box entry subcircuit for sg13cmos5l_and2_2 abstract view
.subckt sg13cmos5l_and2_2 X A B VDD VSS
.ends

* Black-box entry subcircuit for sg13cmos5l_nor2b_1 abstract view
.subckt sg13cmos5l_nor2b_1 Y A B_N VDD VSS
.ends

* Black-box entry subcircuit for sg13cmos5l_a21oi_1 abstract view
.subckt sg13cmos5l_a21oi_1 Y A1 A2 B1 VDD VSS
.ends

* Black-box entry subcircuit for sg13cmos5l_inv_1 abstract view
.subckt sg13cmos5l_inv_1 Y A VDD VSS
.ends

* Black-box entry subcircuit for sg13cmos5l_fill_2 abstract view
.subckt sg13cmos5l_fill_2 VDD VSS
.ends

* Black-box entry subcircuit for sg13cmos5l_xor2_1 abstract view
.subckt sg13cmos5l_xor2_1 X A B VDD VSS
.ends

* Black-box entry subcircuit for sg13cmos5l_nor2_1 abstract view
.subckt sg13cmos5l_nor2_1 Y A B VDD VSS
.ends

* Black-box entry subcircuit for sg13cmos5l_dfrbpq_1 abstract view
.subckt sg13cmos5l_dfrbpq_1 Q CLK D RESET_B VDD VSS
.ends

* Black-box entry subcircuit for sg13cmos5l_mux2_1 abstract view
.subckt sg13cmos5l_mux2_1 X A0 A1 S VDD VSS
.ends

* Black-box entry subcircuit for sg13cmos5l_nand2_2 abstract view
.subckt sg13cmos5l_nand2_2 Y A B VDD VSS
.ends

* Black-box entry subcircuit for sg13cmos5l_decap_8 abstract view
.subckt sg13cmos5l_decap_8 VDD VSS
.ends

* Black-box entry subcircuit for sg13cmos5l_buf_4 abstract view
.subckt sg13cmos5l_buf_4 X A VDD VSS
.ends

* Black-box entry subcircuit for sg13cmos5l_nand2_1 abstract view
.subckt sg13cmos5l_nand2_1 Y A B VDD VSS
.ends

* Black-box entry subcircuit for sg13cmos5l_and2_1 abstract view
.subckt sg13cmos5l_and2_1 X A B VDD VSS
.ends

* Black-box entry subcircuit for sg13cmos5l_nor4_2 abstract view
.subckt sg13cmos5l_nor4_2 Y A B C D VDD VSS
.ends

* Black-box entry subcircuit for sg13cmos5l_and3_1 abstract view
.subckt sg13cmos5l_and3_1 X A B C VDD VSS
.ends

* Black-box entry subcircuit for sg13cmos5l_a22oi_1 abstract view
.subckt sg13cmos5l_a22oi_1 Y A1 A2 B1 B2 VDD VSS
.ends

* Black-box entry subcircuit for sg13cmos5l_fill_1 abstract view
.subckt sg13cmos5l_fill_1 VDD VSS
.ends

* Black-box entry subcircuit for sg13cmos5l_buf_1 abstract view
.subckt sg13cmos5l_buf_1 X A VDD VSS
.ends

* Black-box entry subcircuit for sg13cmos5l_decap_4 abstract view
.subckt sg13cmos5l_decap_4 VDD VSS
.ends

* Black-box entry subcircuit for sg13cmos5l_tiehi abstract view
.subckt sg13cmos5l_tiehi L_HI VDD VSS
.ends

* Black-box entry subcircuit for sg13cmos5l_a21o_1 abstract view
.subckt sg13cmos5l_a21o_1 X A1 A2 B1 VDD VSS
.ends

* Black-box entry subcircuit for sg13cmos5l_nand4_1 abstract view
.subckt sg13cmos5l_nand4_1 Y A B C D VDD VSS
.ends

* Black-box entry subcircuit for sg13cmos5l_nor4_1 abstract view
.subckt sg13cmos5l_nor4_1 Y A B C D VDD VSS
.ends

* Black-box entry subcircuit for sg13cmos5l_or3_1 abstract view
.subckt sg13cmos5l_or3_1 X A B C VDD VSS
.ends

* Black-box entry subcircuit for sg13cmos5l_inv_2 abstract view
.subckt sg13cmos5l_inv_2 Y A VDD VSS
.ends

* Black-box entry subcircuit for sg13cmos5l_nand2b_1 abstract view
.subckt sg13cmos5l_nand2b_1 Y A_N B VDD VSS
.ends

* Black-box entry subcircuit for sg13cmos5l_xnor2_1 abstract view
.subckt sg13cmos5l_xnor2_1 Y A B VDD VSS
.ends

* Black-box entry subcircuit for sg13cmos5l_nand3_1 abstract view
.subckt sg13cmos5l_nand3_1 Y A B C VDD VSS
.ends

* Black-box entry subcircuit for sg13cmos5l_or2_1 abstract view
.subckt sg13cmos5l_or2_1 X A B VDD VSS
.ends

* Black-box entry subcircuit for sg13cmos5l_tielo abstract view
.subckt sg13cmos5l_tielo L_LO VDD VSS
.ends

* Black-box entry subcircuit for sg13cmos5l_nor2_2 abstract view
.subckt sg13cmos5l_nor2_2 Y A B VDD VSS
.ends

* Black-box entry subcircuit for sg13cmos5l_a21oi_2 abstract view
.subckt sg13cmos5l_a21oi_2 Y A1 A2 B1 VDD VSS
.ends

* Black-box entry subcircuit for sg13cmos5l_and4_1 abstract view
.subckt sg13cmos5l_and4_1 X A B C D VDD VSS
.ends

* Black-box entry subcircuit for sg13cmos5l_buf_2 abstract view
.subckt sg13cmos5l_buf_2 X A VDD VSS
.ends

* Black-box entry subcircuit for sg13cmos5l_nand3b_1 abstract view
.subckt sg13cmos5l_nand3b_1 Y A_N B C VDD VSS
.ends

* Black-box entry subcircuit for sg13cmos5l_or4_1 abstract view
.subckt sg13cmos5l_or4_1 X A B C D VDD VSS
.ends

* Black-box entry subcircuit for sg13cmos5l_buf_16 abstract view
.subckt sg13cmos5l_buf_16 X A VDD VSS
.ends

* Black-box entry subcircuit for sg13cmos5l_inv_4 abstract view
.subckt sg13cmos5l_inv_4 Y A VDD VSS
.ends

.subckt heichips26_multimode_dll_small VGND VPWR analog_0 analog_1 analog_2 clk ena
+ rst_n ui_in[0] ui_in[1] ui_in[2] ui_in[3] ui_in[4] ui_in[5] ui_in[6] ui_in[7] uio_in[0]
+ uio_in[1] uio_in[2] uio_in[3] uio_in[4] uio_in[5] uio_in[6] uio_in[7] uio_oe[0]
+ uio_oe[1] uio_oe[2] uio_oe[3] uio_oe[4] uio_oe[5] uio_oe[6] uio_oe[7] uio_out[0]
+ uio_out[1] uio_out[2] uio_out[3] uio_out[4] uio_out[5] uio_out[6] uio_out[7] uo_out[0]
+ uo_out[1] uo_out[2] uo_out[3] uo_out[4] uo_out[5] uo_out[6] uo_out[7]
Xu_dll_u_control__1322_ u_dll_u_control__1323_/D u_dll_u_control__1322_/A u_dll_u_control__2194_/Q
+ u_dll_u_control__1353_/A VPWR VGND sg13cmos5l_nor3_1
Xclkbuf_3_7_0_u_dll\_controller_ring_clk clkbuf_3_7_0_u_dll\_controller_ring_clk/X
+ clkbuf_3_7_0_u_dll\_controller_ring_clk/A VPWR VGND sg13cmos5l_buf_8
Xu_dll_u_control__1184_ u_dll_u_control__1184_/Y u_dll_u_control__1153_/Y u_dll_u_control__1247_/B
+ u_dll_u_control__1183_/X VPWR VGND sg13cmos5l_o21ai_1
Xu_dll_u_control__1253_ u_dll_u_control__1834_/C u_dll_u_control__1245_/S u_dll_u_control__1214_/X
+ u_dll_u_control__1224_/A u_dll_u_control__1224_/B u_dll_u_control__1215_/Y VPWR
+ VGND sg13cmos5l_a221oi_1
Xu_dll_u_div1_u_run_gate_u_and u_dll_u_div1_u_run_gate_u_and/X u_dll_u_div1_u_run_gate_u_and/A
+ u_dll_u_div1__105_/RESET_B VPWR VGND sg13cmos5l_and2_2
Xclkbuf_5_22__f_u_dll\_controller_ref_clk u_dll_u_control__2286_/CLK clkbuf_4_11_0_u_dll\_controller_ref_clk/X
+ VPWR VGND sg13cmos5l_buf_8
Xu_dll_u_div1__065_ u_dll_u_div1__065_/Y u_dll_u_div1__107_/Q u_dll_u_div1__101_/Q
+ VPWR VGND sg13cmos5l_nor2b_1
Xu_dll_u_control__1871_ u_dll_u_control__2273_/D u_dll_u_control__1114_/Y u_dll_u_control__1115_/Y
+ u_dll_u_control__1870_/Y VPWR VGND sg13cmos5l_a21oi_1
Xu_dll_u_control__1940_ u_dll_u_control__1940_/Y u_dll_u_control__2119_/A VPWR VGND
+ sg13cmos5l_inv_1
XFILLER_42_239 VPWR VGND sg13cmos5l_fill_2
Xu_dll_u_control__1305_ u_dll_u_control__1305_/X u_dll_u_control__2147_/Q u_dll_u_control__2321_/Q
+ VPWR VGND sg13cmos5l_xor2_1
Xu_dll_u_control__1236_ u_dll_u_control__1854_/A u_dll_u_control__1876_/A u_dll_u_control__1859_/B
+ VPWR VGND sg13cmos5l_nor2_1
Xu_dll_u_control__2285_ u_dll_u_control__2285_/Q u_dll_u_control__2285_/CLK u_dll_u_control__2285_/D
+ u_dll_u_control__1945_/Y VPWR VGND sg13cmos5l_dfrbpq_1
Xu_dll_u_control__1167_ u_dll_u_control__1171_/B u_dll_u_control__1165_/A u_dll_u_control__1166_/Y
+ u_dll_u_control__1167_/S VPWR VGND sg13cmos5l_mux2_1
Xu_dll_u_div0__083_ u_dll_u_div0__103_/D u_dll_u_div0__088_/A u_dll_u_div0__083_/B
+ VPWR VGND sg13cmos5l_nor2_1
XFILLER_6_129 VPWR VGND sg13cmos5l_fill_2
Xu_dll_u_control__1098_ u_dll_u_control__1098_/Y u_dll_u_control__2271_/Q VPWR VGND
+ sg13cmos5l_inv_1
XFILLER_18_236 VPWR VGND sg13cmos5l_fill_2
XFILLER_26_280 VPWR VGND sg13cmos5l_fill_2
Xu_dll_u_ring_dstage\[0\].id_core_delaymux1_u_merge u_dll_u_ring_dstage\[0\].id_core_long_gate_u_nand/A
+ u_dll_u_ring_dstage\[0\].id_core_delaymux1_u_a0/Y u_dll_u_ring_dstage\[0\].id_core_delaymux1_u_a1/Y
+ VPWR VGND sg13cmos5l_nand2_2
XFILLER_49_383 VPWR VGND sg13cmos5l_decap_8
Xu_dll_u_div1_buffer_u_buf u_dll_u_div1_buffer_u_buf/X u_dll_u_div1_buffer_u_buf/A
+ VPWR VGND sg13cmos5l_buf_4
Xu_dll_u_control__2070_ u_dll_u_control__2070_/Y u_dll_u_control__2125_/A VPWR VGND
+ sg13cmos5l_inv_1
Xu_dll_u_control__1785_ u_dll_u_control__1785_/Y u_dll_u_control__1785_/A u_dll_u_control__1788_/C
+ VPWR VGND sg13cmos5l_nand2_1
Xu_dll_u_control__1854_ u_dll_u_control__2251_/D u_dll_u_control__1854_/A u_dll_u_control__1854_/B
+ VPWR VGND sg13cmos5l_and2_1
Xu_dll_u_control__1923_ u_dll_u_control__1923_/Y u_dll_u_control__2206_/Q u_dll_u_control__1923_/B
+ u_dll_u_control__1923_/C u_dll_u_control__1923_/D VPWR VGND sg13cmos5l_nor4_2
Xu_dll_u_control__1219_ u_dll_u_control__1219_/X u_dll_u_control__2285_/Q u_dll_u_control__2286_/Q
+ u_dll_u_control__1227_/B VPWR VGND sg13cmos5l_and3_1
Xu_dll_u_control__2268_ u_dll_u_control__2268_/Q u_dll_u_control__2268_/CLK u_dll_u_control__2268_/D
+ u_dll_u_control__2125_/Y VPWR VGND sg13cmos5l_dfrbpq_1
Xu_dll_u_control__2199_ u_dll_u_control__2199_/Q u_dll_u_control__2199_/CLK u_dll_u_control__2199_/D
+ u_dll_u_control__2056_/Y VPWR VGND sg13cmos5l_dfrbpq_1
XFILLER_15_206 VPWR VGND sg13cmos5l_decap_8
Xu_dll_u_div0__066_ u_dll_u_div0__066_/Y u_dll_u_div0__102_/Q u_dll_u_div0__063_/Y
+ u_dll_u_div0__065_/Y u_dll_u_div0__054_/Y VPWR VGND sg13cmos5l_a22oi_1
Xu_dll_u_ring_dstage\[5\].id_core_trim_sync\[1\].meta_u_ff u_dll_u_ring_dstage\[5\].id_core_trim_sync\[1\].meta_u_ff/Q
+ u_dll_u_ring_dstage\[5\].id_core_delayinv1_u_inv/Y u_dll_u_control__1073_/Y u_dll_u_ring_dstage\[5\].id_core_trim_reset_inv_u_inv/Y
+ VPWR VGND sg13cmos5l_dfrbpq_1
XFILLER_38_309 VPWR VGND sg13cmos5l_fill_1
Xu_dll_fanout97 u_dll__26_/A u_dll__29_/A VPWR VGND sg13cmos5l_buf_1
XFILLER_46_364 VPWR VGND sg13cmos5l_decap_8
XFILLER_37_320 VPWR VGND sg13cmos5l_decap_4
Xu_dll_u_control__1570_ u_dll_u_control__1624_/A u_dll_u_control__2144_/Q u_dll_u_control__1618_/B
+ VPWR VGND sg13cmos5l_xor2_1
XFILLER_29_0 VPWR VGND sg13cmos5l_fill_2
Xu_dll_u_control__2053_ u_dll_u_control__2053_/Y u_dll_u_control__2064_/A VPWR VGND
+ sg13cmos5l_inv_1
Xu_dll_u_ring_dstage\[0\].id_const0_u_hi u_dll_u_ring_dstage\[0\].id_const0_u_hi/L_HI
+ VPWR VGND sg13cmos5l_tiehi
Xu_dll_u_control__2122_ u_dll_u_control__2122_/Y u_dll_fanout82/X VPWR VGND sg13cmos5l_inv_1
Xu_dll_u_ring_dstage\[9\].id_core_secondary_inv_u_inv u_dll_u_ring_dstage\[9\].id_core_short_decode_u_and/B
+ u_dll_u_ring_dstage\[9\].id_core_long_gate_u_nand/B VPWR VGND sg13cmos5l_inv_1
Xu_dll_u_control__1768_ u_dll_u_control__1768_/Y u_dll_u_control__1752_/A u_dll_u_control__1728_/A
+ u_dll_u_control__1767_/Y u_dll_u_control__1536_/Y VPWR VGND sg13cmos5l_a22oi_1
Xu_dll_u_control__1837_ u_dll_u_control__1837_/Y u_dll_u_control__1859_/A u_dll_u_control__1859_/B
+ u_dll_u_control__1851_/B VPWR VGND sg13cmos5l_o21ai_1
Xu_dll_u_control__1906_ u_dll_u_control__2307_/D u_dll_u_control__2306_/Q u_dll_u_control__2307_/Q
+ u_dll_u_control__1905_/Y VPWR VGND sg13cmos5l_a21oi_1
Xu_dll_u_control__1699_ u_dll_u_control__1700_/C u_dll_u_control__2213_/Q u_dll_u_control__1699_/B
+ VPWR VGND sg13cmos5l_nor2_1
XFILLER_28_397 VPWR VGND sg13cmos5l_decap_8
XFILLER_43_356 VPWR VGND sg13cmos5l_fill_1
Xu_dll_u_div1_u_parity_mux_u_a1 u_dll_u_div1_u_parity_mux_u_a1/Y u_dll_u_div1_u_parity_mux_u_a1/A
+ u_dll_u_div1__106_/Q VPWR VGND sg13cmos5l_nand2_2
Xu_dll_u_div0__049_ u_dll_u_div0__112_/D ui_in[6] VPWR VGND sg13cmos5l_inv_1
XFILLER_7_224 VPWR VGND sg13cmos5l_decap_8
XFILLER_7_235 VPWR VGND sg13cmos5l_fill_1
Xu_dll_u_div0_u_clkbuf_sample_u_buf u_dll_u_div0__115_/CLK u_dll_u_div0_buffer_u_buf/X
+ VPWR VGND sg13cmos5l_buf_4
XFILLER_46_161 VPWR VGND sg13cmos5l_decap_8
Xu_dll__30_ u_dll__30_/Y u_dll__36_/A VPWR VGND sg13cmos5l_inv_1
Xu_dll_u_control__1622_ u_dll_u_control__1623_/B u_dll_u_control__1599_/B u_dll_u_control__1625_/A
+ u_dll_u_control__1619_/Y VPWR VGND sg13cmos5l_a21oi_1
Xu_dll_u_control__1553_ u_dll_u_control__1559_/A u_dll_u_control__1618_/A u_dll_u_control__1552_/Y
+ u_dll_u_control__1789_/B VPWR VGND sg13cmos5l_a21oi_1
XFILLER_29_128 VPWR VGND sg13cmos5l_fill_2
Xu_dll_u_control__1484_ u_dll_u_control__2161_/D u_dll_u_control__1487_/A u_dll_u_control__1484_/B
+ u_dll_u_control__1484_/C VPWR VGND sg13cmos5l_nor3_1
Xu_dll_u_control__2036_ u_dll_u_control__2036_/Y u_dll_fanout80/X VPWR VGND sg13cmos5l_inv_1
Xu_dll_u_ring_dstage\[4\].id_core_delaymux1_u_a1 u_dll_u_ring_dstage\[4\].id_core_delaymux1_u_a1/Y
+ u_dll_u_ring_dstage\[4\].id_core_delaymux1_u_a1/A u_dll_u_ring_dstage\[4\].id_core_delaymux1_u_a1/B
+ VPWR VGND sg13cmos5l_nand2_2
Xu_dll_u_control__2105_ u_dll_u_control__2105_/Y u_dll_u_control__2105_/A VPWR VGND
+ sg13cmos5l_inv_1
XFILLER_0_400 VPWR VGND sg13cmos5l_decap_4
XFILLER_43_131 VPWR VGND sg13cmos5l_fill_1
XFILLER_16_301 VPWR VGND sg13cmos5l_fill_2
Xu_dll_u_ring_iss_core_delaymux1_u_a1 u_dll_u_ring_iss_core_delaymux1_u_a1/Y u_dll_u_ring_iss_core_delaymux1_u_a1/A
+ u_dll_u_ring_iss_core_delaymux1_u_a1/B VPWR VGND sg13cmos5l_nand2_2
XFILLER_6_45 VPWR VGND sg13cmos5l_fill_1
Xu_dll_u_ring_dstage\[2\].id_core_delayint0_u_inv u_dll_u_ring_dstage\[2\].id_core_delaymux1_u_a0/A
+ u_dll_u_ring_dstage\[2\].id_core_delayinv1_u_inv/Y VPWR VGND sg13cmos5l_inv_1
XFILLER_34_164 VPWR VGND sg13cmos5l_fill_1
XFILLER_34_131 VPWR VGND sg13cmos5l_fill_2
XFILLER_22_359 VPWR VGND sg13cmos5l_decap_8
Xu_dll_u_ring_dstage\[1\].id_core_short_decode_u_and u_dll_u_ring_dstage\[1\].id_core_short_gate_u_nand/B
+ u_dll_u_ring_dstage\[1\].id_core_delaymux1_u_a1/B u_dll_u_ring_dstage\[1\].id_core_short_decode_u_and/B
+ VPWR VGND sg13cmos5l_and2_2
Xu_dll_u_control__1605_ u_dll_u_control__1679_/B u_dll_u_control__2321_/Q u_dll_u_control__2320_/Q
+ u_dll_u_control__1605_/C VPWR VGND sg13cmos5l_nor3_1
Xu_dll_u_control__1536_ u_dll_u_control__1536_/Y u_dll_u_control__1742_/A u_dll_u_control__1550_/C
+ VPWR VGND sg13cmos5l_nand2_1
Xu_dll_u_control__1398_ u_dll_u_control__1398_/Y u_dll_u_control__2187_/Q u_dll_u_control__1398_/B
+ VPWR VGND sg13cmos5l_nand2_1
Xu_dll_u_control__1467_ u_dll_u_control__1467_/X u_dll_u_control__1797_/B u_dll_u_control__1469_/B
+ u_dll_u_control__1693_/B VPWR VGND sg13cmos5l_a21o_1
Xu_dll_u_control__2019_ u_dll_u_control__2019_/Y u_dll_u_control__2050_/A VPWR VGND
+ sg13cmos5l_inv_1
Xu_dll_u_div1__081_ u_dll_u_div1__085_/B u_dll_u_div1__103_/Q u_dll_u_div1__084_/C
+ VPWR VGND sg13cmos5l_nand2_1
XFILLER_31_101 VPWR VGND sg13cmos5l_fill_1
XFILLER_31_189 VPWR VGND sg13cmos5l_fill_1
Xclkbuf_2_1_0_u_dll\_controller_ref_clk clkbuf_4_7_0_u_dll\_controller_ref_clk/A clkbuf_2_1_0_u_dll\_controller_ref_clk/A
+ VPWR VGND sg13cmos5l_buf_8
Xu_dll_u_ring_dstage\[5\].id_const0_u_hi u_dll_u_ring_dstage\[5\].id_const0_u_hi/L_HI
+ VPWR VGND sg13cmos5l_tiehi
Xu_dll_u_control__1321_ u_dll_u_control__1353_/A u_dll_u_control__2200_/Q u_dll_u_control__2199_/Q
+ u_dll_u_control__2198_/Q u_dll_u_control__2197_/Q VPWR VGND sg13cmos5l_nand4_1
Xu_dll_u_ring_dstage\[3\].id_core_delaymux1_u_merge u_dll_u_ring_dstage\[3\].id_core_long_gate_u_nand/A
+ u_dll_u_ring_dstage\[3\].id_core_delaymux1_u_a0/Y u_dll_u_ring_dstage\[3\].id_core_delaymux1_u_a1/Y
+ VPWR VGND sg13cmos5l_nand2_2
Xu_dll_u_control__1252_ u_dll_u_control__1262_/B u_dll_u_control__1829_/A u_dll_u_control__1859_/A
+ u_dll_u_control__1834_/B u_dll_u_control__1686_/C VPWR VGND sg13cmos5l_nor4_1
Xu_dll_u_control__1183_ u_dll_u_control__1183_/X u_dll_u_control__1183_/A u_dll_u_control__1183_/B
+ u_dll_u_control__1183_/C VPWR VGND sg13cmos5l_or3_1
XFILLER_10_307 VPWR VGND sg13cmos5l_fill_1
XFILLER_22_134 VPWR VGND sg13cmos5l_fill_1
Xu_dll_u_control__1519_ u_dll_u_control__1528_/B u_dll_u_control__2230_/Q u_dll_u_control__1518_/B
+ u_dll_u_control__1526_/A VPWR VGND sg13cmos5l_o21ai_1
XFILLER_26_31 VPWR VGND sg13cmos5l_fill_2
XFILLER_3_68 VPWR VGND sg13cmos5l_fill_1
Xu_dll_u_div1__064_ u_dll_u_div1__064_/Y u_dll_u_div1__106_/Q u_dll_u_div1__107_/Q
+ VPWR VGND sg13cmos5l_nand2_1
XFILLER_36_204 VPWR VGND sg13cmos5l_fill_1
Xu_dll_u_ring_dstage\[9\].id_core_trim_reset_inv_u_inv u_dll_u_ring_dstage\[9\].id_core_trim_reset_inv_u_inv/Y
+ u_dll_u_ring_trim_reset_buffers\[3\].u_buffer_u_buf/X VPWR VGND sg13cmos5l_inv_2
Xu_dll_u_control__1870_ u_dll_u_control__1870_/Y u_dll_u_control__1114_/Y u_dll_u_control__1115_/Y
+ u_dll_u_control__1878_/B VPWR VGND sg13cmos5l_o21ai_1
XFILLER_35_292 VPWR VGND sg13cmos5l_fill_1
Xu_dll_u_control__1304_ u_dll_u_control__1304_/Y u_dll_u_control__1926_/A u_dll_u_control__2149_/Q
+ VPWR VGND sg13cmos5l_nand2b_1
Xu_dll_u_control__2284_ u_dll_u_control__2284_/Q u_dll_u_control__2286_/CLK u_dll_u_control__2284_/D
+ u_dll_u_control__1944_/Y VPWR VGND sg13cmos5l_dfrbpq_1
Xu_dll_u_control__1235_ u_dll_u_control__1859_/B u_dll_u_control__1867_/A u_dll_u_control__1841_/C
+ VPWR VGND sg13cmos5l_nand2_1
Xu_dll_u_div0__082_ u_dll_u_div0__083_/B u_dll_u_div0__103_/Q u_dll_u_div0__084_/C
+ VPWR VGND sg13cmos5l_xnor2_1
Xu_dll_u_control__1097_ u_dll_u_control__1097_/Y u_dll_u_control__2281_/Q VPWR VGND
+ sg13cmos5l_inv_1
Xu_dll_u_control__1166_ u_dll_u_control__1166_/Y u_dll_u_control__2145_/Q u_dll_u_control__1166_/B
+ VPWR VGND sg13cmos5l_xnor2_1
Xu_dll_u_ring_dstage\[5\].id_core_trim_sync\[0\].meta_u_ff u_dll_u_ring_dstage\[5\].id_core_trim_sync\[0\].meta_u_ff/Q
+ u_dll_u_ring_dstage\[5\].id_core_delayinv1_u_inv/Y u_dll_u_control__2251_/Q u_dll_u_ring_dstage\[5\].id_core_trim_reset_inv_u_inv/Y
+ VPWR VGND sg13cmos5l_dfrbpq_1
Xu_dll_u_control__1999_ u_dll_u_control__1999_/Y u_dll_u_control__1999_/A VPWR VGND
+ sg13cmos5l_inv_1
XFILLER_2_369 VPWR VGND sg13cmos5l_decap_4
Xu_dll_u_ring_dstage\[0\].id_core_trim_sync\[1\].meta_u_ff u_dll_u_ring_dstage\[0\].id_core_trim_sync\[1\].meta_u_ff/Q
+ u_dll_u_ring_dstage\[0\].id_core_delayinv1_u_inv/Y u_dll_u_control__1078_/Y u_dll_u_ring_dstage\[0\].id_core_trim_reset_inv_u_inv/Y
+ VPWR VGND sg13cmos5l_dfrbpq_1
Xu_dll_u_ring_dstage\[0\].id_core_merge_gate_u_nand u_dll_u_ring_dstage\[0\].id_core_reset_gate_u_aoi/B1
+ u_dll_u_ring_dstage\[0\].id_core_short_gate_u_nand/Y u_dll_u_ring_dstage\[0\].id_core_long_gate_u_nand/Y
+ u_dll_u_ring_dstage\[0\].id_core_reset_inv_u_inv/Y VPWR VGND sg13cmos5l_nand3_1
XFILLER_49_362 VPWR VGND sg13cmos5l_decap_8
Xu_dll_u_control__1922_ u_dll_u_control__1923_/D u_dll_u_control__2204_/Q u_dll_u_control__2203_/Q
+ u_dll_u_control__2202_/Q VPWR VGND sg13cmos5l_nand3_1
Xu_dll_u_control__1784_ u_dll_u_control__1788_/C u_dll_u_control__1784_/A u_dll_u_control__1784_/B
+ VPWR VGND sg13cmos5l_or2_1
Xu_dll_u_control__1853_ u_dll_u_control__1854_/B u_dll_u_control__1284_/B u_dll_u_control__1864_/B
+ u_dll_u_control__1829_/X VPWR VGND sg13cmos5l_o21ai_1
Xu_dll_u_control__1149_ u_dll_u_control__1149_/X u_dll_u_control__2286_/Q u_dll_u_control__1170_/B
+ VPWR VGND sg13cmos5l_and2_1
Xu_dll_u_control__1218_ u_dll_u_control__1238_/A u_dll_u_control__1829_/A u_dll_u_control__1846_/A
+ VPWR VGND sg13cmos5l_nor2_1
Xu_dll_u_control__2267_ u_dll_u_control__2267_/Q clkload5/A u_dll_u_control__2267_/D
+ u_dll_u_control__2124_/Y VPWR VGND sg13cmos5l_dfrbpq_1
Xu_dll_u_control__2198_ u_dll_u_control__2198_/Q u_dll_u_control__2199_/CLK u_dll_u_control__2198_/D
+ u_dll_u_control__2055_/Y VPWR VGND sg13cmos5l_dfrbpq_1
Xu_dll_fanout98 u_dll__29_/A u_dll_fanout98/A VPWR VGND sg13cmos5l_buf_1
Xu_dll_u_div0__065_ u_dll_u_div0__065_/Y u_dll_u_div0__107_/Q u_dll_u_div0__101_/Q
+ VPWR VGND sg13cmos5l_nor2b_1
XFILLER_48_73 VPWR VGND sg13cmos5l_fill_2
XFILLER_0_25 VPWR VGND sg13cmos5l_fill_1
XFILLER_0_14 VPWR VGND sg13cmos5l_decap_8
XFILLER_0_36 VPWR VGND sg13cmos5l_decap_8
XFILLER_0_47 VPWR VGND sg13cmos5l_fill_1
XFILLER_49_181 VPWR VGND sg13cmos5l_fill_1
Xu_dll_u_control__2052_ u_dll_u_control__2052_/Y u_dll_u_control__2060_/A VPWR VGND
+ sg13cmos5l_inv_1
Xu_dll_u_control__2121_ u_dll_u_control__2121_/Y u_dll_fanout82/X VPWR VGND sg13cmos5l_inv_1
Xu_dll_u_control__1905_ u_dll_u_control__1905_/Y u_dll_u_control__1909_/A u_dll_u_control__1905_/B
+ VPWR VGND sg13cmos5l_nand2_1
Xu_dll_u_control__1698_ u_dll_u_control__2212_/D u_dll_u_control__1699_/B u_dll_u_control__1702_/A
+ u_dll_u_control__1698_/C VPWR VGND sg13cmos5l_nor3_1
Xu_dll_u_control__1767_ u_dll_u_control__1767_/Y u_dll_u_control__1537_/B u_dll_u_control__1725_/B
+ u_dll_u_control__1772_/B u_dll_u_control__1730_/B VPWR VGND sg13cmos5l_a22oi_1
Xu_dll_u_control__1836_ u_dll_u_control__1840_/A u_dll_u_control__1834_/C u_dll_u_control__1267_/Y
+ u_dll_u_control__1271_/Y u_dll_u_control__1833_/Y u_dll_u_control__1687_/B VPWR
+ VGND sg13cmos5l_a221oi_1
Xu_dll_u_control__2319_ u_dll_u_control__2319_/Q u_dll_u_control__2319_/CLK u_dll_u_control__2319_/D
+ u_dll_u_control__1979_/Y VPWR VGND sg13cmos5l_dfrbpq_1
XFILLER_43_379 VPWR VGND sg13cmos5l_decap_8
XFILLER_34_64 VPWR VGND sg13cmos5l_decap_4
XFILLER_38_118 VPWR VGND sg13cmos5l_decap_8
Xclkbuf_4_11_0_u_dll\_controller_ref_clk clkbuf_4_11_0_u_dll\_controller_ref_clk/X
+ clkbuf_4_9_0_u_dll\_controller_ref_clk/A VPWR VGND sg13cmos5l_buf_8
Xu_dll_u_control__1225__123 u_dll_u_control__1225_/B VPWR VGND sg13cmos5l_tiehi
XFILLER_6_280 VPWR VGND sg13cmos5l_fill_2
Xu_dll_u_control__1621_ u_dll_u_control__1625_/B u_dll_u_control__2142_/Q u_dll_u_control__1629_/B
+ VPWR VGND sg13cmos5l_xor2_1
Xu_dll_u_control__1552_ u_dll_u_control__1552_/Y u_dll_u_control__2143_/Q u_dll_u_control__1552_/B
+ u_dll_u_control__1552_/C VPWR VGND sg13cmos5l_nor3_1
XFILLER_29_107 VPWR VGND sg13cmos5l_fill_1
XFILLER_37_173 VPWR VGND sg13cmos5l_fill_2
XFILLER_37_162 VPWR VGND sg13cmos5l_decap_8
Xu_dll_u_control__1483_ u_dll_u_control__1484_/C u_dll_u_control__2161_/Q u_dll_u_control__1507_/B
+ VPWR VGND sg13cmos5l_nor2_1
Xu_dll_u_control__2104_ u_dll_u_control__2104_/Y u_dll_u_control__2105_/A VPWR VGND
+ sg13cmos5l_inv_1
Xu_dll_u_control__2035_ u_dll_u_control__2035_/Y u_dll_u_control__2035_/A VPWR VGND
+ sg13cmos5l_inv_1
Xu_dll_u_ring_dstage\[6\].id_core_delaymux1_u_merge u_dll_u_ring_dstage\[6\].id_core_long_gate_u_nand/A
+ u_dll_u_ring_dstage\[6\].id_core_delaymux1_u_a0/Y u_dll_u_ring_dstage\[6\].id_core_delaymux1_u_a1/Y
+ VPWR VGND sg13cmos5l_nand2_2
XFILLER_4_239 VPWR VGND sg13cmos5l_decap_8
Xu_dll_u_ring_u_clkbuf_u_buf u_dll_u_div1_buffer_u_buf/A u_dll_u_ring_u_clkbuf_u_buf/A
+ VPWR VGND sg13cmos5l_buf_8
Xu_dll_u_control__1819_ u_dll_u_control__1819_/Y u_dll_u_control__1816_/X u_dll_u_control__1818_/X
+ u_dll_u_control__1919_/B VPWR VGND sg13cmos5l_o21ai_1
XFILLER_43_154 VPWR VGND sg13cmos5l_fill_1
XFILLER_16_335 VPWR VGND sg13cmos5l_decap_4
Xu_dll_u_ring_dstage\[3\].id_core_delayinv1_u_inv u_dll_u_ring_dstage\[3\].id_core_delayinv1_u_inv/Y
+ u_dll_u_ring_dstage\[3\].id_core_delayinv1_u_inv/A VPWR VGND sg13cmos5l_inv_2
Xu_dll_u_ring_dstage\[1\].id_core_secondary_inv_u_inv u_dll_u_ring_dstage\[1\].id_core_short_decode_u_and/B
+ u_dll_u_ring_dstage\[1\].id_core_long_gate_u_nand/B VPWR VGND sg13cmos5l_inv_1
XFILLER_13_4 VPWR VGND sg13cmos5l_fill_2
XFILLER_34_154 VPWR VGND sg13cmos5l_decap_4
XFILLER_22_338 VPWR VGND sg13cmos5l_decap_8
XFILLER_30_393 VPWR VGND sg13cmos5l_decap_8
Xu_dll_u_control__1604_ u_dll_u_control__1604_/X u_dll_u_control__1616_/B u_dll_u_control__1616_/C
+ VPWR VGND sg13cmos5l_or2_1
Xu_dll_u_control__1535_ u_dll_u_control__1550_/C u_dll_u_control__2228_/Q u_dll_u_control__1535_/B
+ VPWR VGND sg13cmos5l_xor2_1
Xu_dll_u_control__1397_ u_dll_u_control__2188_/D u_dll_u_control__1355_/Y u_dll_u_control__1397_/A2
+ u_dll_u_control__1396_/Y VPWR VGND sg13cmos5l_o21ai_1
Xu_dll_u_control__1466_ u_dll_u_control__1466_/Y u_dll_u_control__1797_/B u_dll_u_control__1469_/B
+ u_dll_u_control__1693_/B VPWR VGND sg13cmos5l_a21oi_1
Xu_dll_u_control__2018_ u_dll_u_control__2018_/Y u_dll_u_control__2050_/A VPWR VGND
+ sg13cmos5l_inv_1
Xu_dll_u_div1__080_ u_dll_u_div1__102_/D u_dll_u_div1__088_/A u_dll_u_div1__084_/C
+ u_dll_u_div1__080_/C VPWR VGND sg13cmos5l_nor3_1
Xclkbuf_5_27__f_u_dll\_controller_ref_clk u_dll_u_control__2275_/CLK clkbuf_4_13_0_u_dll\_controller_ref_clk/X
+ VPWR VGND sg13cmos5l_buf_8
XFILLER_8_353 VPWR VGND sg13cmos5l_fill_1
XFILLER_8_397 VPWR VGND sg13cmos5l_decap_8
Xu_dll_u_ring_dstage\[3\].id_core_merge_gate_u_nand u_dll_u_ring_dstage\[3\].id_core_reset_gate_u_aoi/B1
+ u_dll_u_ring_dstage\[3\].id_core_short_gate_u_nand/Y u_dll_u_ring_dstage\[3\].id_core_long_gate_u_nand/Y
+ u_dll_u_ring_dstage\[3\].id_core_reset_inv_u_inv/Y VPWR VGND sg13cmos5l_nand3_1
Xu_dll_u_control__1182_ u_dll_u_control__1247_/B u_dll_u_control__2281_/Q u_dll_u_control__1183_/A
+ VPWR VGND sg13cmos5l_xor2_1
Xu_dll_u_control__1251_ u_dll_u_control__1864_/A u_dll_u_control__1846_/A u_dll_u_control__1846_/B
+ VPWR VGND sg13cmos5l_nand2_1
Xu_dll_u_control__1320_ u_dll_u_control__1320_/Y u_dll_u_control__2201_/Q u_dll_u_control__1392_/B
+ VPWR VGND sg13cmos5l_nand2_1
Xu_dll_u_ring_dstage\[0\].id_core_trim_sync\[0\].meta_u_ff u_dll_u_ring_dstage\[0\].id_core_trim_sync\[0\].meta_u_ff/Q
+ u_dll_u_ring_dstage\[0\].id_core_delayinv1_u_inv/Y u_dll_u_control__2246_/Q u_dll_u_ring_dstage\[0\].id_core_trim_reset_inv_u_inv/Y
+ VPWR VGND sg13cmos5l_dfrbpq_1
Xu_dll_u_control__1518_ u_dll_u_control__1530_/B u_dll_u_control__1526_/A u_dll_u_control__1518_/B
+ VPWR VGND sg13cmos5l_nand2_1
Xu_dll_u_control__1449_ u_dll_u_control__1449_/Y u_dll_u_control__2172_/Q u_dll_u_control__1454_/B
+ u_dll_u_control__1420_/B VPWR VGND sg13cmos5l_o21ai_1
XFILLER_42_75 VPWR VGND sg13cmos5l_decap_8
XFILLER_3_14 VPWR VGND sg13cmos5l_decap_8
Xu_dll_u_div1__063_ u_dll_u_div1__063_/Y u_dll_u_div1__101_/Q u_dll_u_div1__107_/Q
+ VPWR VGND sg13cmos5l_nand2b_1
XFILLER_32_400 VPWR VGND sg13cmos5l_decap_4
Xu_dll_u_control__1303_ u_dll_u_control__1303_/Y u_dll_u_control__2149_/Q u_dll_u_control__1926_/A
+ VPWR VGND sg13cmos5l_nand2b_1
Xu_dll_u_control__1165_ u_dll_u_control__1201_/A u_dll_u_control__1165_/A u_dll_u_control__1166_/B
+ VPWR VGND sg13cmos5l_xnor2_1
Xu_dll_u_control__1234_ u_dll_u_control__1687_/B u_dll_u_control__1867_/A u_dll_u_control__1841_/C
+ VPWR VGND sg13cmos5l_and2_1
Xu_dll_u_ring_dstage\[6\].id_core_trim_sync\[1\].applied_u_ff u_dll_u_ring_dstage\[6\].id_core_long_gate_u_nand/B
+ u_dll_u_ring_dstage\[6\].id_core_delayinv1_u_inv/Y u_dll_u_ring_dstage\[6\].id_core_trim_sync\[1\].meta_u_ff/Q
+ u_dll_u_ring_dstage\[6\].id_core_trim_reset_inv_u_inv/Y VPWR VGND sg13cmos5l_dfrbpq_1
Xu_dll_u_control__2283_ u_dll_u_control__2283_/Q u_dll_u_control__2285_/CLK u_dll_u_control__2283_/D
+ u_dll_u_control__1943_/Y VPWR VGND sg13cmos5l_dfrbpq_1
Xu_dll_u_div0__081_ u_dll_u_div0__085_/B u_dll_u_div0__103_/Q u_dll_u_div0__084_/C
+ VPWR VGND sg13cmos5l_nand2_1
Xu_dll_u_control__1096_ u_dll_u_control__1227_/A u_dll_u_control__2285_/Q VPWR VGND
+ sg13cmos5l_inv_1
Xu_dll_u_control__1998_ u_dll_u_control__1998_/Y u_dll_u_control__1999_/A VPWR VGND
+ sg13cmos5l_inv_1
XFILLER_37_97 VPWR VGND sg13cmos5l_decap_8
Xu_dll_u_ring_dstage\[11\].id_core_secondary_inv_u_inv u_dll_u_ring_dstage\[11\].id_core_short_decode_u_and/B
+ u_dll_u_ring_dstage\[11\].id_core_long_gate_u_nand/B VPWR VGND sg13cmos5l_inv_1
Xu_dll_u_ring_dstage\[6\].id_core_delaymux1_u_sel u_dll_u_ring_dstage\[6\].id_core_delaymux1_u_a0/B
+ u_dll_u_ring_dstage\[6\].id_core_delaymux1_u_a1/B VPWR VGND sg13cmos5l_inv_1
XFILLER_18_216 VPWR VGND sg13cmos5l_fill_2
XFILLER_49_341 VPWR VGND sg13cmos5l_decap_8
XFILLER_49_330 VPWR VGND sg13cmos5l_decap_8
Xu_dll_u_div1__115_ u_dll_u_div1__115_/Q u_dll_u_div1__115_/CLK uio_in[6] u_dll_u_div1_fanout60/X
+ VPWR VGND sg13cmos5l_dfrbpq_1
XFILLER_1_381 VPWR VGND sg13cmos5l_decap_8
Xclkbuf_4_14_0_u_dll\_controller_ref_clk clkbuf_4_14_0_u_dll\_controller_ref_clk/X
+ clkbuf_2_3_0_u_dll\_controller_ref_clk/X VPWR VGND sg13cmos5l_buf_8
XFILLER_32_252 VPWR VGND sg13cmos5l_fill_1
XFILLER_20_403 VPWR VGND sg13cmos5l_fill_1
Xu_dll_u_control__1921_ u_dll_u_control__2313_/D u_dll_u_control__2129_/Q u_dll_u_control__1921_/B
+ VPWR VGND sg13cmos5l_and2_1
Xu_dll_u_ring_dstage\[1\].id_core_short_gate_u_nand u_dll_u_ring_dstage\[1\].id_core_short_gate_u_nand/Y
+ u_dll_u_ring_dstage\[0\].id_core_reset_gate_u_aoi/Y u_dll_u_ring_dstage\[1\].id_core_short_gate_u_nand/B
+ VPWR VGND sg13cmos5l_nand2_1
Xu_dll_u_control__1783_ u_dll_u_control__1783_/Y u_dll_u_control__1783_/A u_dll_u_control__1788_/B
+ VPWR VGND sg13cmos5l_nand2_1
Xu_dll_u_control__1852_ u_dll_u_control__2252_/D u_dll_u_control__1840_/A u_dll_u_control__1850_/X
+ u_dll_u_control__1851_/Y u_dll_u_control__1837_/Y VPWR VGND sg13cmos5l_a22oi_1
Xu_dll_u_control__2266_ u_dll_u_control__2266_/Q u_dll_u_control__2266_/CLK u_dll_u_control__2266_/D
+ u_dll_u_control__2123_/Y VPWR VGND sg13cmos5l_dfrbpq_1
Xu_dll_u_control__1148_ u_dll_u_control__1170_/B u_dll_u_control__1166_/B u_dll_u_control__1167_/S
+ u_dll_u_control__2145_/Q VPWR VGND sg13cmos5l_a21o_1
Xu_dll_u_control__1217_ u_dll_u_control__1846_/A u_dll_u_control__1245_/S u_dll_u_control__1214_/X
+ u_dll_u_control__1215_/Y VPWR VGND sg13cmos5l_a21oi_1
Xu_dll_u_control__1079_ u_dll_u_control__1923_/B u_dll_u_control__2205_/Q VPWR VGND
+ sg13cmos5l_inv_1
Xu_dll_u_control__2197_ u_dll_u_control__2197_/Q u_dll_u_control__2199_/CLK u_dll_u_control__2197_/D
+ u_dll_u_control__2054_/Y VPWR VGND sg13cmos5l_dfrbpq_1
Xu_dll_u_ring_dstage\[9\].id_core_delaymux1_u_merge u_dll_u_ring_dstage\[9\].id_core_long_gate_u_nand/A
+ u_dll_u_ring_dstage\[9\].id_core_delaymux1_u_a0/Y u_dll_u_ring_dstage\[9\].id_core_delaymux1_u_a1/Y
+ VPWR VGND sg13cmos5l_nand2_2
Xu_dll_u_div0__064_ u_dll_u_div0__064_/Y u_dll_u_div0__106_/Q u_dll_u_div0__107_/Q
+ VPWR VGND sg13cmos5l_nand2_1
Xu_dll_fanout99 u_dll__26_/B u_dll__29_/B VPWR VGND sg13cmos5l_buf_1
XFILLER_46_399 VPWR VGND sg13cmos5l_decap_4
XFILLER_14_241 VPWR VGND sg13cmos5l_fill_1
Xu_dll_u_control__2120_ u_dll_u_control__2120_/Y u_dll_fanout82/X VPWR VGND sg13cmos5l_inv_1
Xu_dll_u_control__2051_ u_dll_u_control__2051_/Y u_dll_u_control__2060_/A VPWR VGND
+ sg13cmos5l_inv_1
Xu_dll_u_ring_dstage\[0\].id_const0_u_lo u_dll_u_ring_dstage\[0\].id_const0_u_lo/L_LO
+ VPWR VGND sg13cmos5l_tielo
Xu_dll_u_control__1835_ u_dll_u_control__1858_/A u_dll_u_control__1834_/C u_dll_u_control__1267_/Y
+ u_dll_u_control__1687_/B VPWR VGND sg13cmos5l_a21oi_1
Xu_dll_u_control__1904_ u_dll_u_control__1905_/B u_dll_u_control__2306_/Q u_dll_u_control__2307_/Q
+ VPWR VGND sg13cmos5l_or2_1
Xu_dll_u_control__1766_ u_dll_u_control__1766_/Y u_dll_u_control__1785_/A u_dll_u_control__1783_/A
+ u_dll_u_control__1766_/C VPWR VGND sg13cmos5l_nand3_1
Xu_dll_u_control__1697_ u_dll_u_control__1698_/C u_dll_u_control__2211_/Q u_dll_u_control__2210_/Q
+ u_dll_u_control__2212_/Q VPWR VGND sg13cmos5l_a21oi_1
XFILLER_43_347 VPWR VGND sg13cmos5l_decap_8
Xu_dll_u_control__2318_ u_dll_u_control__2318_/Q u_dll_u_control__2319_/CLK u_dll_u_control__2318_/D
+ u_dll_u_control__1978_/Y VPWR VGND sg13cmos5l_dfrbpq_1
Xu_dll_u_control__2249_ u_dll_u_control__2249_/Q u_dll_u_control__2266_/CLK u_dll_u_control__2249_/D
+ u_dll_u_control__2106_/Y VPWR VGND sg13cmos5l_dfrbpq_1
XFILLER_11_233 VPWR VGND sg13cmos5l_decap_8
XFILLER_1_0 VPWR VGND sg13cmos5l_fill_2
Xu_dll_u_ring_dstage\[6\].id_core_reset_inv_u_inv u_dll_u_ring_dstage\[6\].id_core_reset_inv_u_inv/Y
+ u_dll_u_ring_dstage\[6\].id_const0_u_lo/L_LO VPWR VGND sg13cmos5l_inv_1
Xu_dll_u_ring_dstage\[2\].id_core_fast_decode_u_nor u_dll_u_ring_dstage\[2\].id_core_reset_gate_u_aoi/A2
+ u_dll_u_ring_dstage\[2\].id_core_delaymux1_u_a1/B u_dll_u_ring_dstage\[2\].id_core_long_gate_u_nand/B
+ VPWR VGND sg13cmos5l_nor2_2
Xclkbuf_4_15__f_u_dll\_controller_ring_clk clkload8/A clkbuf_3_7_0_u_dll\_controller_ring_clk/X
+ VPWR VGND sg13cmos5l_buf_8
XFILLER_19_399 VPWR VGND sg13cmos5l_decap_4
Xu_dll_u_control__1551_ u_dll_u_control__1552_/C u_dll_u_control__2141_/Q u_dll_u_control__2140_/Q
+ VPWR VGND sg13cmos5l_nand2_1
Xu_dll_u_control__1620_ u_dll_u_control__1625_/A u_dll_u_control__1629_/B u_dll_u_control__1552_/C
+ u_dll_u_control__1599_/A VPWR VGND sg13cmos5l_a21o_1
Xu_dll_u_ring_dstage\[6\].id_core_merge_gate_u_nand u_dll_u_ring_dstage\[6\].id_core_reset_gate_u_aoi/B1
+ u_dll_u_ring_dstage\[6\].id_core_short_gate_u_nand/Y u_dll_u_ring_dstage\[6\].id_core_long_gate_u_nand/Y
+ u_dll_u_ring_dstage\[6\].id_core_reset_inv_u_inv/Y VPWR VGND sg13cmos5l_nand3_1
Xu_dll_u_control__1482_ u_dll_u_control__1484_/B u_dll_u_control__2189_/Q u_dll_u_control__1485_/B
+ VPWR VGND sg13cmos5l_nor2_1
Xu_dll_u_ring_dstage\[6\].id_core_short_decode_u_and u_dll_u_ring_dstage\[6\].id_core_short_gate_u_nand/B
+ u_dll_u_ring_dstage\[6\].id_core_delaymux1_u_a1/B u_dll_u_ring_dstage\[6\].id_core_short_decode_u_and/B
+ VPWR VGND sg13cmos5l_and2_2
Xu_dll_u_control__2103_ u_dll_u_control__2103_/Y u_dll_u_control__2105_/A VPWR VGND
+ sg13cmos5l_inv_1
Xu_dll_u_control__2034_ u_dll_u_control__2034_/Y u_dll_u_control__2034_/A VPWR VGND
+ sg13cmos5l_inv_1
XFILLER_4_218 VPWR VGND sg13cmos5l_decap_8
Xu_dll_u_control__1818_ u_dll_u_control__1818_/X u_dll_u_control__2164_/Q u_dll_u_control__1925_/A
+ VPWR VGND sg13cmos5l_xor2_1
Xu_dll_u_control__1749_ u_dll_u_control__2238_/D u_dll_u_control__1913_/A u_dll_u_control__1760_/A
+ u_dll_u_control__1788_/A VPWR VGND sg13cmos5l_nor3_1
XFILLER_45_97 VPWR VGND sg13cmos5l_decap_4
XFILLER_43_111 VPWR VGND sg13cmos5l_decap_4
XFILLER_34_144 VPWR VGND sg13cmos5l_fill_2
XFILLER_19_163 VPWR VGND sg13cmos5l_fill_1
XFILLER_34_177 VPWR VGND sg13cmos5l_decap_8
XFILLER_30_372 VPWR VGND sg13cmos5l_fill_2
XFILLER_22_317 VPWR VGND sg13cmos5l_decap_8
Xu_dll_u_control__1603_ u_dll_u_control__1616_/C u_dll_u_control__1618_/A u_dll_u_control__1618_/B
+ u_dll_u_control__1618_/C VPWR VGND sg13cmos5l_a21oi_1
Xu_dll_u_control__1534_ u_dll_u_control__1772_/A u_dll_u_control__2228_/Q u_dll_u_control__1535_/B
+ VPWR VGND sg13cmos5l_xnor2_1
Xu_dll_u_ring_dstage\[5\].id_core_delaybuf1_u_buf u_dll_u_ring_dstage\[5\].id_core_delayinv1_u_inv/A
+ u_dll_u_ring_dstage\[5\].id_core_delaymux1_u_a1/A VPWR VGND sg13cmos5l_buf_1
Xu_dll_u_control__1465_ u_dll_u_control__1693_/B u_dll_u_control__2217_/Q u_dll_u_control__1465_/B
+ VPWR VGND sg13cmos5l_nand2_1
Xu_dll_u_control__1396_ u_dll_u_control__1396_/Y u_dll_u_control__2188_/Q u_dll_u_control__1398_/B
+ VPWR VGND sg13cmos5l_nand2_1
XFILLER_25_111 VPWR VGND sg13cmos5l_fill_2
XFILLER_31_99 VPWR VGND sg13cmos5l_fill_2
Xu_dll_u_control__2017_ u_dll_u_control__2017_/Y u_dll_u_control__2085_/A VPWR VGND
+ sg13cmos5l_inv_1
XFILLER_0_210 VPWR VGND sg13cmos5l_fill_1
Xu_dll_u_ring_dstage\[5\].id_const0_u_lo u_dll_u_ring_dstage\[5\].id_const0_u_lo/L_LO
+ VPWR VGND sg13cmos5l_tielo
Xu_dll_u_control__1181_ u_dll_u_control__1181_/X u_dll_u_control__1200_/A u_dll_u_control__1200_/B
+ VPWR VGND sg13cmos5l_and2_1
Xu_dll_u_control__1250_ u_dll_u_control__1846_/B u_dll_u_control__1247_/Y u_dll_u_control__1248_/Y
+ u_dll_u_control__1246_/X VPWR VGND sg13cmos5l_a21o_1
Xu_dll_u_ring_dstage\[4\].id_core_short_gate_u_nand u_dll_u_ring_dstage\[4\].id_core_short_gate_u_nand/Y
+ u_dll_u_ring_dstage\[3\].id_core_reset_gate_u_aoi/Y u_dll_u_ring_dstage\[4\].id_core_short_gate_u_nand/B
+ VPWR VGND sg13cmos5l_nand2_1
Xu_dll_u_control__1517_ u_dll_u_control__1518_/B u_dll_u_control__2229_/Q u_dll_u_control__1529_/B
+ VPWR VGND sg13cmos5l_nand2b_1
Xu_dll_u_control__1448_ u_dll_u_control__1454_/B u_dll_u_control__2171_/Q u_dll_u_control__1456_/B
+ VPWR VGND sg13cmos5l_and2_1
XFILLER_26_11 VPWR VGND sg13cmos5l_decap_8
XFILLER_26_33 VPWR VGND sg13cmos5l_fill_1
XFILLER_26_66 VPWR VGND sg13cmos5l_decap_8
XFILLER_42_54 VPWR VGND sg13cmos5l_fill_1
Xu_dll_u_control__1379_ u_dll_u_control__1381_/B u_dll_u_control__1382_/A u_dll_u_control__1379_/B
+ VPWR VGND sg13cmos5l_nor2_1
XFILLER_26_77 VPWR VGND sg13cmos5l_fill_2
XFILLER_26_99 VPWR VGND sg13cmos5l_fill_2
XFILLER_42_98 VPWR VGND sg13cmos5l_decap_8
XFILLER_21_191 VPWR VGND sg13cmos5l_fill_2
Xu_dll_u_div1__062_ u_dll_u_div1__070_/B u_dll_u_div1__062_/A u_dll_u_div1__062_/B
+ VPWR VGND sg13cmos5l_xnor2_1
XFILLER_3_59 VPWR VGND sg13cmos5l_fill_2
XFILLER_3_48 VPWR VGND sg13cmos5l_decap_4
Xu_dll_u_ring_dstage\[1\].id_core_trim_sync\[1\].applied_u_ff u_dll_u_ring_dstage\[1\].id_core_long_gate_u_nand/B
+ u_dll_u_ring_dstage\[1\].id_core_delayinv1_u_inv/Y u_dll_u_ring_dstage\[1\].id_core_trim_sync\[1\].meta_u_ff/Q
+ u_dll_u_ring_dstage\[1\].id_core_trim_reset_inv_u_inv/Y VPWR VGND sg13cmos5l_dfrbpq_1
Xu_dll_u_control__2282_ u_dll_u_control__2282_/Q u_dll_u_control__2286_/CLK u_dll_u_control__2282_/D
+ u_dll_u_control__1942_/Y VPWR VGND sg13cmos5l_dfrbpq_1
Xu_dll_u_control__1302_ u_dll_u_control__1309_/C u_dll_u_control__2146_/Q u_dll_u_control__2320_/Q
+ VPWR VGND sg13cmos5l_nand2b_1
Xu_dll_u_control__1164_ u_dll_u_control__1164_/Y u_dll_u_control__2284_/Q u_dll_u_control__1163_/X
+ u_dll_u_control__1162_/Y VPWR VGND sg13cmos5l_o21ai_1
Xu_dll_u_control__1233_ u_dll_u_control__2285_/D u_dll_u_control__1233_/A VPWR VGND
+ sg13cmos5l_inv_1
Xu_dll_u_control__1095_ u_dll_u_control__1682_/B u_dll_u_control__2311_/Q VPWR VGND
+ sg13cmos5l_inv_1
Xu_dll_u_control__1997_ u_dll_u_control__1997_/Y u_dll_u_control__1999_/A VPWR VGND
+ sg13cmos5l_inv_1
Xu_dll_u_div0__080_ u_dll_u_div0__102_/D u_dll_u_div0__088_/A u_dll_u_div0__084_/C
+ u_dll_u_div0__080_/C VPWR VGND sg13cmos5l_nor3_1
XFILLER_18_206 VPWR VGND sg13cmos5l_fill_2
XFILLER_37_54 VPWR VGND sg13cmos5l_fill_2
XFILLER_41_264 VPWR VGND sg13cmos5l_decap_4
XFILLER_41_253 VPWR VGND sg13cmos5l_decap_8
XFILLER_49_397 VPWR VGND sg13cmos5l_decap_8
Xu_dll_u_div1__114_ u_dll_u_div1__114_/Q u_dll_u_div1__115_/CLK uio_in[5] u_dll_fanout61/X
+ VPWR VGND sg13cmos5l_dfrbpq_1
Xu_dll_u_ring_dstage\[5\].id_core_fast_decode_u_nor u_dll_u_ring_dstage\[5\].id_core_reset_gate_u_aoi/A2
+ u_dll_u_ring_dstage\[5\].id_core_delaymux1_u_a1/B u_dll_u_ring_dstage\[5\].id_core_long_gate_u_nand/B
+ VPWR VGND sg13cmos5l_nor2_2
Xu_dll_u_control__1851_ u_dll_u_control__1851_/Y u_dll_u_control__1851_/A u_dll_u_control__1851_/B
+ u_dll_u_control__1851_/C VPWR VGND sg13cmos5l_nand3_1
Xu_dll_u_control__1920_ u_dll_u_control__2314_/D u_dll_u_control__1921_/B u_dll_u_control__2313_/Q
+ VPWR VGND sg13cmos5l_and2_1
Xu_dll_u_control__1782_ u_dll_u_control__1788_/B u_dll_u_control__1299_/Y u_dll_u_control__1780_/Y
+ u_dll_u_control__1781_/Y VPWR VGND sg13cmos5l_o21ai_1
Xu_dll_u_ring_dstage\[9\].id_core_merge_gate_u_nand u_dll_u_ring_dstage\[9\].id_core_reset_gate_u_aoi/B1
+ u_dll_u_ring_dstage\[9\].id_core_short_gate_u_nand/Y u_dll_u_ring_dstage\[9\].id_core_long_gate_u_nand/Y
+ u_dll_u_ring_dstage\[9\].id_core_reset_inv_u_inv/Y VPWR VGND sg13cmos5l_nand3_1
Xu_dll_u_control__1216_ u_dll_u_control__1857_/A u_dll_u_control__1245_/S u_dll_u_control__1214_/X
+ u_dll_u_control__1215_/Y VPWR VGND sg13cmos5l_a21o_1
Xu_dll_u_control__2265_ u_dll_u_control__2265_/Q u_dll_u_control__2266_/CLK u_dll_u_control__2265_/D
+ u_dll_u_control__2122_/Y VPWR VGND sg13cmos5l_dfrbpq_1
Xu_dll_u_control__1147_ u_dll_u_control__1167_/S u_dll_u_control__2144_/Q u_dll_u_control__1147_/B
+ u_dll_u_control__1147_/C u_dll_u_control__1147_/D VPWR VGND sg13cmos5l_nand4_1
Xu_dll_u_div0__063_ u_dll_u_div0__063_/Y u_dll_u_div0__101_/Q u_dll_u_div0__107_/Q
+ VPWR VGND sg13cmos5l_nand2b_1
Xu_dll_u_control__2196_ u_dll_u_control__2196_/Q u_dll_u_control__2207_/CLK u_dll_u_control__2196_/D
+ u_dll_u_control__2053_/Y VPWR VGND sg13cmos5l_dfrbpq_1
XFILLER_23_275 VPWR VGND sg13cmos5l_fill_1
Xu_dll_u_control__1078_ u_dll_u_control__1078_/Y u_dll_u_control__2259_/Q VPWR VGND
+ sg13cmos5l_inv_1
Xclkbuf_4_0_0_u_dll\_controller_ref_clk clkbuf_4_0_0_u_dll\_controller_ref_clk/X clkbuf_4_3_0_u_dll\_controller_ref_clk/A
+ VPWR VGND sg13cmos5l_buf_8
Xu_dll_u_ring_iss_core_secondary_inv_u_inv u_dll_u_ring_iss_core_short_decode_u_and/B
+ u_dll_u_ring_iss_core_long_gate_u_nand/B VPWR VGND sg13cmos5l_inv_1
XFILLER_48_75 VPWR VGND sg13cmos5l_fill_1
XFILLER_46_378 VPWR VGND sg13cmos5l_decap_8
XFILLER_14_275 VPWR VGND sg13cmos5l_fill_2
Xu_dll_u_control__2050_ u_dll_u_control__2050_/Y u_dll_u_control__2050_/A VPWR VGND
+ sg13cmos5l_inv_1
XFILLER_20_212 VPWR VGND sg13cmos5l_fill_2
Xu_dll_u_control__1834_ u_dll_u_control__1844_/C u_dll_u_control__1834_/A u_dll_u_control__1834_/B
+ u_dll_u_control__1834_/C VPWR VGND sg13cmos5l_nand3_1
Xu_dll_u_control__1903_ u_dll_u_control__2306_/D u_dll_u_control__1913_/A u_dll_u_control__2306_/Q
+ VPWR VGND sg13cmos5l_nor2_1
XFILLER_9_290 VPWR VGND sg13cmos5l_fill_1
Xu_dll_u_control__1765_ u_dll_u_control__1776_/A u_dll_u_control__1783_/A u_dll_u_control__1766_/C
+ VPWR VGND sg13cmos5l_nand2_1
Xu_dll_u_control__1696_ u_dll_u_control__2211_/D u_dll_u_control__1702_/A u_dll_u_control__1696_/B
+ VPWR VGND sg13cmos5l_nor2_1
XFILLER_28_301 VPWR VGND sg13cmos5l_fill_2
XFILLER_18_45 VPWR VGND sg13cmos5l_fill_1
Xu_dll_u_control__2317_ u_dll_u_control__2317_/Q u_dll_u_control__2317_/CLK u_dll_u_control__2317_/D
+ u_dll_u_control__1977_/Y VPWR VGND sg13cmos5l_dfrbpq_1
Xu_dll_u_control__2179_ u_dll_u_control__2179_/Q u_dll_u_control__2179_/CLK u_dll_u_control__2179_/D
+ u_dll_u_control__2036_/Y VPWR VGND sg13cmos5l_dfrbpq_1
XFILLER_11_212 VPWR VGND sg13cmos5l_decap_8
XFILLER_18_78 VPWR VGND sg13cmos5l_fill_2
Xu_dll_u_control__2248_ u_dll_u_control__2248_/Q u_dll_u_control__2268_/CLK u_dll_u_control__2248_/D
+ u_dll_u_control__2105_/Y VPWR VGND sg13cmos5l_dfrbpq_1
Xu_dll_u_div0__115_ u_dll_u_div0__115_/Q u_dll_u_div0__115_/CLK uio_in[1] u_dll_fanout61/X
+ VPWR VGND sg13cmos5l_dfrbpq_1
XFILLER_3_400 VPWR VGND sg13cmos5l_decap_4
XFILLER_11_256 VPWR VGND sg13cmos5l_fill_2
Xu_dll_u_ring_dstage\[7\].id_core_delaymux1_u_a0 u_dll_u_ring_dstage\[7\].id_core_delaymux1_u_a0/Y
+ u_dll_u_ring_dstage\[7\].id_core_delaymux1_u_a0/A u_dll_u_ring_dstage\[7\].id_core_delaymux1_u_a0/B
+ VPWR VGND sg13cmos5l_nand2_2
Xu_dll_u_control__1550_ u_dll_u_control__1560_/A u_dll_u_control__1746_/A u_dll_u_control__1735_/B
+ u_dll_u_control__1550_/C u_dll_u_control__1550_/D VPWR VGND sg13cmos5l_nand4_1
Xu_dll_u_control__1481_ u_dll_u_control__2162_/D u_dll_u_control__1487_/A u_dll_u_control__1481_/B
+ u_dll_u_control__1481_/C VPWR VGND sg13cmos5l_nor3_1
Xu_dll_u_control__2102_ u_dll_u_control__2102_/Y u_dll_u_control__2102_/A VPWR VGND
+ sg13cmos5l_inv_1
XFILLER_37_186 VPWR VGND sg13cmos5l_fill_1
Xu_dll_u_control__2033_ u_dll_u_control__2033_/Y u_dll_u_control__2034_/A VPWR VGND
+ sg13cmos5l_inv_1
Xu_dll_u_control__1748_ u_dll_u_control__1750_/B u_dll_u_control__1760_/A u_dll_u_control__1788_/A
+ VPWR VGND sg13cmos5l_nor2_1
Xu_dll_u_ring_dstage\[7\].id_core_short_gate_u_nand u_dll_u_ring_dstage\[7\].id_core_short_gate_u_nand/Y
+ u_dll_u_ring_dstage\[6\].id_core_reset_gate_u_aoi/Y u_dll_u_ring_dstage\[7\].id_core_short_gate_u_nand/B
+ VPWR VGND sg13cmos5l_nand2_1
Xu_dll_u_control__1817_ u_dll_u_control__1817_/Y u_dll_u_control__1925_/A u_dll_u_control__2164_/Q
+ VPWR VGND sg13cmos5l_nand2b_1
XFILLER_43_123 VPWR VGND sg13cmos5l_fill_1
Xu_dll_u_control__1679_ u_dll_u_control__1679_/Y u_dll_u_control__1679_/A u_dll_u_control__1679_/B
+ VPWR VGND sg13cmos5l_nand2_1
XFILLER_45_87 VPWR VGND sg13cmos5l_fill_1
XFILLER_45_76 VPWR VGND sg13cmos5l_fill_2
XFILLER_30_384 VPWR VGND sg13cmos5l_decap_4
Xu_dll_u_control__1602_ u_dll_u_control__1618_/C u_dll_u_control__2144_/Q u_dll_u_control__1618_/B
+ u_dll_u_control__1601_/X VPWR VGND sg13cmos5l_a21oi_1
Xu_dll_u_control__1533_ u_dll_u_control__1533_/Y u_dll_u_control__1730_/B VPWR VGND
+ sg13cmos5l_inv_1
Xu_dll_u_control__1464_ u_dll_u_control__2166_/D u_dll_u_control__2301_/Q u_dll_u_control__1464_/A2
+ u_dll_u_control__1463_/X u_dll_u_control__1683_/A u_dll_u_control__1899_/A VPWR
+ VGND sg13cmos5l_a221oi_1
Xu_dll_u_control__1395_ u_dll_u_control__2189_/D u_dll_u_control__1349_/B u_dll_u_control__1397_/A2
+ u_dll_u_control__1394_/Y VPWR VGND sg13cmos5l_o21ai_1
Xu_dll_u_control__2016_ u_dll_u_control__2016_/Y u_dll_u_control__2085_/A VPWR VGND
+ sg13cmos5l_inv_1
Xu_dll_u_ring_iss_core_trim_sync\[0\].applied_u_ff u_dll_u_ring_iss_core_delaymux1_u_a1/B
+ u_dll_u_ring_iss_core_delayinv1_u_inv/Y u_dll_u_ring_iss_core_trim_sync\[0\].meta_u_ff/Q
+ u_dll_u_ring_iss_core_trim_reset_inv_u_inv/Y VPWR VGND sg13cmos5l_dfrbpq_1
XFILLER_48_215 VPWR VGND sg13cmos5l_fill_1
XFILLER_31_159 VPWR VGND sg13cmos5l_decap_8
Xu_dll_u_ring_dstage\[8\].id_core_fast_decode_u_nor u_dll_u_ring_dstage\[8\].id_core_reset_gate_u_aoi/A2
+ u_dll_u_ring_dstage\[8\].id_core_delaymux1_u_a1/B u_dll_u_ring_dstage\[8\].id_core_long_gate_u_nand/B
+ VPWR VGND sg13cmos5l_nor2_2
Xu_dll_u_control__1180_ u_dll_u_control__1200_/B u_dll_u_control__2286_/Q u_dll_u_control__1180_/B
+ VPWR VGND sg13cmos5l_xnor2_1
XFILLER_22_148 VPWR VGND sg13cmos5l_decap_4
XFILLER_41_402 VPWR VGND sg13cmos5l_fill_2
XFILLER_38_270 VPWR VGND sg13cmos5l_fill_2
Xu_dll_u_control__1516_ u_dll_u_control__1529_/B u_dll_u_control__2228_/Q u_dll_u_control__1515_/B
+ u_dll_u_control__1526_/A VPWR VGND sg13cmos5l_o21ai_1
Xu_dll_u_control__1378_ u_dll_u_control__1379_/B u_dll_u_control__2195_/Q u_dll_u_control__2194_/Q
+ VPWR VGND sg13cmos5l_xor2_1
Xu_dll_u_control__1447_ u_dll_u_control__1456_/B u_dll_u_control__2170_/Q u_dll_u_control__1458_/B
+ VPWR VGND sg13cmos5l_and2_1
Xu_dll_u_div1__061_ u_dll_u_div1__061_/Y u_dll_u_div1__110_/Q u_dll_u_div1__072_/B
+ VPWR VGND sg13cmos5l_nor2b_1
Xclkbuf_4_3_0_u_dll\_controller_ref_clk clkbuf_4_3_0_u_dll\_controller_ref_clk/X clkbuf_4_3_0_u_dll\_controller_ref_clk/A
+ VPWR VGND sg13cmos5l_buf_8
XFILLER_44_251 VPWR VGND sg13cmos5l_fill_1
Xu_dll_u_control__2281_ u_dll_u_control__2281_/Q u_dll_u_control__2286_/CLK u_dll_u_control__2281_/D
+ u_dll_u_control__1941_/Y VPWR VGND sg13cmos5l_dfrbpq_1
Xu_dll_u_control__1232_ u_dll_u_control__1233_/A u_dll_u_control__1851_/B u_dll_u_control__1841_/C
+ VPWR VGND sg13cmos5l_nand2_1
Xu_dll_u_control__1301_ u_dll_u_control__1301_/Y u_dll_u_control__1085_/Y u_dll_u_control__1752_/A
+ u_dll_u_control__2146_/Q VPWR VGND sg13cmos5l_a21oi_1
Xu_dll_u_control__1163_ u_dll_u_control__1163_/X u_dll_u_control__1163_/A u_dll_u_control__1163_/B
+ VPWR VGND sg13cmos5l_xor2_1
Xu_dll_u_control__1309__125 u_dll_u_control__1309_/B VPWR VGND sg13cmos5l_tiehi
Xu_dll_u_control__1094_ u_dll_u_control__1094_/Y u_dll_u_control__2312_/Q VPWR VGND
+ sg13cmos5l_inv_1
Xu_dll_u_control__1996_ u_dll_u_control__1996_/Y u_dll_u_control__1996_/A VPWR VGND
+ sg13cmos5l_inv_1
XFILLER_2_328 VPWR VGND sg13cmos5l_fill_2
XFILLER_49_310 VPWR VGND sg13cmos5l_decap_4
XFILLER_49_376 VPWR VGND sg13cmos5l_decap_8
Xu_dll_u_div1__113_ u_dll_u_div1__113_/Q u_dll_u_div1__115_/CLK uio_in[4] u_dll_u_div1_fanout60/X
+ VPWR VGND sg13cmos5l_dfrbpq_1
XFILLER_32_298 VPWR VGND sg13cmos5l_fill_2
Xclkbuf_5_1__f_u_dll\_controller_ref_clk clkload0/A clkbuf_4_0_0_u_dll\_controller_ref_clk/X
+ VPWR VGND sg13cmos5l_buf_8
XFILLER_17_295 VPWR VGND sg13cmos5l_decap_8
Xu_dll_u_control__1781_ u_dll_u_control__1781_/Y u_dll_u_control__1299_/A u_dll_u_control__1744_/B
+ u_dll_u_control__1533_/Y u_dll_u_control__1752_/A VPWR VGND sg13cmos5l_a22oi_1
Xu_dll_u_control__1850_ u_dll_u_control__1850_/X u_dll_u_control__1864_/A u_dll_u_control__1850_/B
+ u_dll_u_control__1864_/C VPWR VGND sg13cmos5l_or3_1
Xu_dll_u_control__1215_ u_dll_u_control__1215_/Y u_dll_u_control__1215_/A u_dll_u_control__1245_/S
+ VPWR VGND sg13cmos5l_nor2_1
Xu_dll_u_control__2195_ u_dll_u_control__2195_/Q u_dll_u_control__2207_/CLK u_dll_u_control__2195_/D
+ u_dll_u_control__2052_/Y VPWR VGND sg13cmos5l_dfrbpq_1
Xu_dll_u_ring_dstage\[0\].id_core_long_gate_u_nand u_dll_u_ring_dstage\[0\].id_core_long_gate_u_nand/Y
+ u_dll_u_ring_dstage\[0\].id_core_long_gate_u_nand/A u_dll_u_ring_dstage\[0\].id_core_long_gate_u_nand/B
+ VPWR VGND sg13cmos5l_nand2_2
Xu_dll_u_control__2264_ u_dll_u_control__2264_/Q clkload4/A u_dll_u_control__2264_/D
+ u_dll_u_control__2121_/Y VPWR VGND sg13cmos5l_dfrbpq_1
Xu_dll_u_control__1146_ u_dll_u_control__1163_/B u_dll_u_control__1147_/B u_dll_u_control__1147_/C
+ u_dll_u_control__1147_/D VPWR VGND sg13cmos5l_nand3_1
Xu_dll_u_div0__062_ u_dll_u_div0__070_/B u_dll_u_div0__062_/A u_dll_u_div0__062_/B
+ VPWR VGND sg13cmos5l_xnor2_1
Xu_dll_u_control__1077_ u_dll_u_control__1077_/Y u_dll_u_control__2260_/Q VPWR VGND
+ sg13cmos5l_inv_1
XFILLER_23_35 VPWR VGND sg13cmos5l_decap_4
Xu_dll_u_control__1979_ u_dll_u_control__1979_/Y u_dll_u_control__2063_/A VPWR VGND
+ sg13cmos5l_inv_1
XFILLER_46_357 VPWR VGND sg13cmos5l_decap_8
Xclkbuf_4_3__f_u_dll\_controller_ring_clk u_dll_u_control__2206_/CLK clkbuf_3_1_0_u_dll\_controller_ring_clk/X
+ VPWR VGND sg13cmos5l_buf_8
XFILLER_37_324 VPWR VGND sg13cmos5l_fill_2
Xu_dll_u_control__1902_ u_dll_u_control__2301_/D u_dll_u_control__1445_/C u_dll_u_control__1901_/Y
+ u_dll_u_control__1456_/A VPWR VGND sg13cmos5l_a21oi_1
XFILLER_9_280 VPWR VGND sg13cmos5l_fill_1
Xu_dll_u_control__1764_ u_dll_u_control__1766_/C u_dll_u_control__1764_/A u_dll_u_control__1764_/B
+ VPWR VGND sg13cmos5l_or2_1
Xu_dll_u_control__1833_ u_dll_u_control__1833_/Y u_dll_u_control__1857_/A u_dll_u_control__1833_/B
+ u_dll_u_control__1833_/C VPWR VGND sg13cmos5l_nor3_1
Xu_dll_u_control__2316_ u_dll_u_control__2316_/Q u_dll_u_control__2316_/CLK u_dll_u_control__2316_/D
+ u_dll_u_control__1976_/Y VPWR VGND sg13cmos5l_dfrbpq_1
Xu_dll_u_control__1695_ u_dll_u_control__1696_/B u_dll_u_control__2211_/Q u_dll_u_control__2210_/Q
+ VPWR VGND sg13cmos5l_xnor2_1
XFILLER_28_368 VPWR VGND sg13cmos5l_fill_2
Xu_dll_u_ring_dstage\[10\].id_core_short_decode_u_and u_dll_u_ring_dstage\[10\].id_core_short_gate_u_nand/B
+ u_dll_u_ring_dstage\[10\].id_core_delaymux1_u_a1/B u_dll_u_ring_dstage\[10\].id_core_short_decode_u_and/B
+ VPWR VGND sg13cmos5l_and2_2
Xu_dll_u_control__1129_ u_dll_u_control__1885_/A u_dll_u_control__1884_/A u_dll_u_control__1884_/B
+ u_dll_u_control__1884_/C VPWR VGND sg13cmos5l_a21o_1
Xu_dll_u_control__2247_ u_dll_u_control__2247_/Q clkload4/A u_dll_u_control__2247_/D
+ u_dll_u_control__2104_/Y VPWR VGND sg13cmos5l_dfrbpq_1
Xu_dll_u_control__2178_ u_dll_u_control__2178_/Q u_dll_u_control__2299_/CLK u_dll_u_control__2178_/D
+ u_dll_u_control__2035_/Y VPWR VGND sg13cmos5l_dfrbpq_1
Xu_dll_u_div0__114_ u_dll_u_div0__114_/Q u_dll_u_div0__115_/CLK uio_in[0] u_dll_fanout61/X
+ VPWR VGND sg13cmos5l_dfrbpq_1
XFILLER_7_217 VPWR VGND sg13cmos5l_decap_8
Xclkload0 clkload0/Y clkload0/A VPWR VGND sg13cmos5l_inv_1
XFILLER_46_154 VPWR VGND sg13cmos5l_fill_2
XFILLER_46_121 VPWR VGND sg13cmos5l_decap_8
Xu_dll_u_ring_dstage\[7\].id_core_delaymux1_u_a1 u_dll_u_ring_dstage\[7\].id_core_delaymux1_u_a1/Y
+ u_dll_u_ring_dstage\[7\].id_core_delaymux1_u_a1/A u_dll_u_ring_dstage\[7\].id_core_delaymux1_u_a1/B
+ VPWR VGND sg13cmos5l_nand2_2
Xu_dll_u_control__1480_ u_dll_u_control__1481_/C u_dll_u_control__2162_/Q u_dll_u_control__1507_/B
+ VPWR VGND sg13cmos5l_nor2_1
Xu_dll_u_control__2101_ u_dll_u_control__2101_/Y u_dll_u_control__2102_/A VPWR VGND
+ sg13cmos5l_inv_1
Xu_dll_u_control__2032_ u_dll_u_control__2032_/Y u_dll_u_control__2034_/A VPWR VGND
+ sg13cmos5l_inv_1
Xu_dll_u_control__1747_ u_dll_u_control__1788_/A u_dll_u_control__1783_/A VPWR VGND
+ sg13cmos5l_inv_1
Xu_dll_u_control__1678_ u_dll_u_control__2129_/D u_dll_u_control__2129_/Q u_dll_u_control__1469_/Y
+ u_dll_u_control__1677_/Y VPWR VGND sg13cmos5l_a21oi_1
Xu_dll_u_control__1816_ u_dll_u_control__1816_/X u_dll_u_control__1816_/A u_dll_u_control__1816_/B
+ VPWR VGND sg13cmos5l_and2_1
Xu_dll_u_div1_u_valid_gate_u_and u_dll_u_div1_u_bypass_mux_u_a0/A u_dll_u_div1_u_valid_gate_u_and/A
+ u_dll_u_div1__058_/Y VPWR VGND sg13cmos5l_and2_2
Xclkbuf_5_12__f_u_dll\_controller_ref_clk u_dll_u_control__2231_/CLK clkbuf_4_6_0_u_dll\_controller_ref_clk/X
+ VPWR VGND sg13cmos5l_buf_8
Xu_dll_u_ring_dstage\[5\].id_core_trim_sync\[0\].applied_u_ff u_dll_u_ring_dstage\[5\].id_core_delaymux1_u_a1/B
+ u_dll_u_ring_dstage\[5\].id_core_delayinv1_u_inv/Y u_dll_u_ring_dstage\[5\].id_core_trim_sync\[0\].meta_u_ff/Q
+ u_dll_u_ring_dstage\[5\].id_core_trim_reset_inv_u_inv/Y VPWR VGND sg13cmos5l_dfrbpq_1
XFILLER_43_179 VPWR VGND sg13cmos5l_fill_1
XFILLER_3_286 VPWR VGND sg13cmos5l_fill_2
XFILLER_19_143 VPWR VGND sg13cmos5l_fill_1
XFILLER_34_146 VPWR VGND sg13cmos5l_fill_1
Xclkbuf_4_6_0_u_dll\_controller_ref_clk clkbuf_4_6_0_u_dll\_controller_ref_clk/X clkbuf_4_7_0_u_dll\_controller_ref_clk/A
+ VPWR VGND sg13cmos5l_buf_8
Xu_dll_u_control__1601_ u_dll_u_control__1601_/X u_dll_u_control__1624_/A u_dll_u_control__1624_/B
+ VPWR VGND sg13cmos5l_and2_1
Xu_dll_u_control__1532_ u_dll_u_control__1730_/B u_dll_u_control__2227_/Q u_dll_u_control__1532_/B
+ VPWR VGND sg13cmos5l_xor2_1
Xu_dll_u_control__1463_ u_dll_u_control__1463_/X u_dll_u_control__2296_/Q u_dll_u_control__1463_/B
+ VPWR VGND sg13cmos5l_or2_1
Xu_dll_u_control__1394_ u_dll_u_control__1394_/Y u_dll_u_control__2189_/Q u_dll_u_control__1410_/B
+ VPWR VGND sg13cmos5l_nand2_1
Xu_dll_u_control__2015_ u_dll_u_control__2015_/Y u_dll_u_control__2042_/A VPWR VGND
+ sg13cmos5l_inv_1
Xu_dll_u_control__1690__126 u_dll_u_control__1690_/B VPWR VGND sg13cmos5l_tiehi
Xu_dll_u_ring_dstage\[5\].id_core_delayint0_u_inv u_dll_u_ring_dstage\[5\].id_core_delaymux1_u_a0/A
+ u_dll_u_ring_dstage\[5\].id_core_delayinv1_u_inv/Y VPWR VGND sg13cmos5l_inv_1
XFILLER_16_179 VPWR VGND sg13cmos5l_fill_1
XFILLER_24_190 VPWR VGND sg13cmos5l_fill_1
XFILLER_47_293 VPWR VGND sg13cmos5l_decap_4
Xu_dll_u_ring_dstage\[10\].id_core_delaymux1_u_sel u_dll_u_ring_dstage\[10\].id_core_delaymux1_u_a0/B
+ u_dll_u_ring_dstage\[10\].id_core_delaymux1_u_a1/B VPWR VGND sg13cmos5l_inv_1
Xu_dll_u_control__1515_ u_dll_u_control__1535_/B u_dll_u_control__1526_/A u_dll_u_control__1515_/B
+ VPWR VGND sg13cmos5l_nand2_1
Xu_dll_u_control__1446_ u_dll_u_control__1458_/B u_dll_u_control__2169_/Q u_dll_u_control__1460_/A
+ VPWR VGND sg13cmos5l_and2_1
Xu_dll_u_control__1377_ u_dll_u_control__2196_/D u_dll_u_control__1384_/A u_dll_u_control__1377_/B
+ u_dll_u_control__1377_/C VPWR VGND sg13cmos5l_nor3_1
XFILLER_26_24 VPWR VGND sg13cmos5l_decap_8
Xu_dll_u_div1__060_ u_dll_u_div1__072_/B u_dll_u_div1__109_/Q u_dll_u_div1__108_/Q
+ u_dll_u_div1__106_/Q u_dll_u_div1__060_/D VPWR VGND sg13cmos5l_nor4_1
XFILLER_36_219 VPWR VGND sg13cmos5l_fill_2
Xu_dll_u_control__1162_ u_dll_u_control__1162_/Y u_dll_u_control__1189_/A u_dll_u_control__1163_/B
+ u_dll_u_control__1162_/C VPWR VGND sg13cmos5l_nand3_1
Xu_dll_u_control__1231_ u_dll_u_control__1833_/C u_dll_u_control__1228_/Y u_dll_u_control__1229_/Y
+ u_dll_u_control__1230_/Y VPWR VGND sg13cmos5l_o21ai_1
Xu_dll_u_control__2280_ u_dll_u_control__2280_/Q u_dll_u_control__2280_/CLK u_dll_u_control__2280_/D
+ u_dll_u_control__1940_/Y VPWR VGND sg13cmos5l_dfrbpq_1
Xu_dll_u_control__1300_ u_dll_u_control__1605_/C u_dll_u_control__1300_/A u_dll_u_control__1537_/B
+ VPWR VGND sg13cmos5l_nand2_1
Xu_dll_u_ring_dstage\[8\].id_core_secondary_inv_u_inv u_dll_u_ring_dstage\[8\].id_core_short_decode_u_and/B
+ u_dll_u_ring_dstage\[8\].id_core_long_gate_u_nand/B VPWR VGND sg13cmos5l_inv_1
Xu_dll_u_control__1093_ u_dll_u_control__1093_/Y u_dll_u_control__2316_/Q VPWR VGND
+ sg13cmos5l_inv_1
Xu_dll_u_control__1995_ u_dll_u_control__1995_/Y u_dll_u_control__1996_/A VPWR VGND
+ sg13cmos5l_inv_1
XFILLER_18_208 VPWR VGND sg13cmos5l_fill_1
XFILLER_41_211 VPWR VGND sg13cmos5l_fill_1
Xu_dll_u_control__1429_ u_dll_u_control__1442_/B u_dll_u_control__2174_/Q u_dll_u_control__1444_/B
+ VPWR VGND sg13cmos5l_and2_1
XFILLER_14_403 VPWR VGND sg13cmos5l_fill_1
XFILLER_49_355 VPWR VGND sg13cmos5l_decap_8
XFILLER_49_300 VPWR VGND sg13cmos5l_decap_4
Xu_dll_u_div1__112_ u_dll_u_div1__112_/Q u_dll_u_div1__115_/CLK u_dll_u_div1__112_/D
+ u_dll_fanout61/X VPWR VGND sg13cmos5l_dfrbpq_1
XFILLER_1_395 VPWR VGND sg13cmos5l_decap_8
Xu_dll_u_control__1780_ u_dll_u_control__1780_/Y u_dll_u_control__1537_/B u_dll_u_control__1772_/A
+ u_dll_u_control__1772_/B u_dll_u_control__1531_/B VPWR VGND sg13cmos5l_a22oi_1
Xu_dll_u_control__1145_ u_dll_u_control__1147_/D u_dll_u_control__2142_/Q u_dll_u_control__2141_/Q
+ u_dll_u_control__1183_/B u_dll_u_control__1183_/C VPWR VGND sg13cmos5l_nor4_1
Xu_dll_u_control__1214_ u_dll_u_control__1214_/X u_dll_u_control__1163_/A u_dll_u_control__1213_/Y
+ u_dll_u_control__1247_/A VPWR VGND sg13cmos5l_mux2_1
Xu_dll_u_control__2194_ u_dll_u_control__2194_/Q u_dll_u_control__2207_/CLK u_dll_u_control__2194_/D
+ u_dll_u_control__2051_/Y VPWR VGND sg13cmos5l_dfrbpq_1
Xu_dll_u_ring_dstage\[10\].id_core_reset_inv_u_inv u_dll_u_ring_dstage\[10\].id_core_reset_inv_u_inv/Y
+ u_dll_u_ring_dstage\[10\].id_const0_u_lo/L_LO VPWR VGND sg13cmos5l_inv_1
Xu_dll_u_control__2263_ u_dll_u_control__2263_/Q u_dll_u_control__2266_/CLK u_dll_u_control__2263_/D
+ u_dll_u_control__2120_/Y VPWR VGND sg13cmos5l_dfrbpq_1
Xu_dll_u_div0__061_ u_dll_u_div0__061_/Y u_dll_u_div0__110_/Q u_dll_u_div0__072_/B
+ VPWR VGND sg13cmos5l_nor2b_1
Xu_dll_u_control__1076_ u_dll_u_control__1076_/Y u_dll_u_control__2261_/Q VPWR VGND
+ sg13cmos5l_inv_1
XFILLER_2_126 VPWR VGND sg13cmos5l_fill_1
Xu_dll_u_control__1978_ u_dll_u_control__1978_/Y u_dll_u_control__2060_/A VPWR VGND
+ sg13cmos5l_inv_1
XFILLER_0_29 VPWR VGND sg13cmos5l_decap_8
Xu_dll_u_ring_dstage\[4\].id_core_reset_gate_u_aoi u_dll_u_ring_dstage\[4\].id_core_reset_gate_u_aoi/Y
+ u_dll_u_ring_dstage\[3\].id_core_reset_gate_u_aoi/Y u_dll_u_ring_dstage\[4\].id_core_reset_gate_u_aoi/A2
+ u_dll_u_ring_dstage\[4\].id_core_reset_gate_u_aoi/B1 VPWR VGND sg13cmos5l_a21oi_2
XFILLER_45_391 VPWR VGND sg13cmos5l_decap_8
XFILLER_37_369 VPWR VGND sg13cmos5l_fill_1
Xclkbuf_4_9_0_u_dll\_controller_ref_clk clkbuf_4_9_0_u_dll\_controller_ref_clk/X clkbuf_4_9_0_u_dll\_controller_ref_clk/A
+ VPWR VGND sg13cmos5l_buf_8
Xu_dll_u_control__1901_ u_dll_u_control__1901_/Y u_dll_u_control__2175_/Q u_dll_u_control__2174_/Q
+ u_dll_u_control__1901_/C u_dll_u_control__1901_/D VPWR VGND sg13cmos5l_nand4_1
Xu_dll_u_control__1694_ u_dll_u_control__2210_/D u_dll_u_control__2210_/Q u_dll_u_control__1702_/A
+ VPWR VGND sg13cmos5l_nor2_1
Xu_dll_u_control__1763_ u_dll_u_control__2240_/D u_dll_u_control__1913_/A u_dll_u_control__1788_/A
+ u_dll_u_control__1763_/C u_dll_u_control__1763_/D VPWR VGND sg13cmos5l_nor4_1
Xu_dll_u_control__1832_ u_dll_u_control__2257_/D u_dll_u_control__1844_/B u_dll_u_control__1826_/X
+ u_dll_u_control__1828_/Y u_dll_u_control__1829_/X u_dll_u_control__1860_/A VPWR
+ VGND sg13cmos5l_a221oi_1
XFILLER_43_339 VPWR VGND sg13cmos5l_fill_2
XFILLER_28_314 VPWR VGND sg13cmos5l_fill_2
Xu_dll_u_control__2315_ u_dll_u_control__2315_/Q u_dll_u_control__2315_/CLK u_dll_u_control__2315_/D
+ u_dll_u_control__1975_/Y VPWR VGND sg13cmos5l_dfrbpq_1
Xu_dll_u_control__1128_ u_dll_u_control__1142_/C u_dll_u_control__1884_/A u_dll_u_control__1884_/B
+ u_dll_u_control__1884_/C VPWR VGND sg13cmos5l_a21oi_1
Xu_dll_u_div0__113_ u_dll_u_div0__113_/Q u_dll_u_div0__115_/CLK ui_in[7] u_dll_u_div0_fanout59/X
+ VPWR VGND sg13cmos5l_dfrbpq_1
XFILLER_34_68 VPWR VGND sg13cmos5l_fill_1
Xu_dll_u_control__2177_ u_dll_u_control__2177_/Q u_dll_u_control__2301_/CLK u_dll_u_control__2177_/D
+ u_dll_u_control__2034_/Y VPWR VGND sg13cmos5l_dfrbpq_1
Xclkload1 clkload1/Y clkload1/A VPWR VGND sg13cmos5l_inv_1
Xu_dll_u_control__2246_ u_dll_u_control__2246_/Q u_dll_u_control__2268_/CLK u_dll_u_control__2246_/D
+ u_dll_u_control__2103_/Y VPWR VGND sg13cmos5l_dfrbpq_1
Xclkbuf_1_1_0_u_dll\_controller_ref_clk clkbuf_2_3_0_u_dll\_controller_ref_clk/A clkbuf_0_u_dll\_controller_ref_clk/X
+ VPWR VGND sg13cmos5l_buf_8
XFILLER_10_280 VPWR VGND sg13cmos5l_fill_2
XFILLER_6_273 VPWR VGND sg13cmos5l_decap_8
Xu_dll_u_control__2100_ u_dll_u_control__2100_/Y u_dll_u_control__2102_/A VPWR VGND
+ sg13cmos5l_inv_1
XFILLER_37_155 VPWR VGND sg13cmos5l_decap_8
XFILLER_37_111 VPWR VGND sg13cmos5l_decap_4
Xu_dll_u_control__2031_ u_dll_u_control__2031_/Y u_dll_u_control__2034_/A VPWR VGND
+ sg13cmos5l_inv_1
Xclkbuf_3_3_0_u_dll\_controller_ring_clk clkbuf_3_3_0_u_dll\_controller_ring_clk/X
+ clkbuf_3_3_0_u_dll\_controller_ring_clk/A VPWR VGND sg13cmos5l_buf_8
Xu_dll_u_ring_dstage\[0\].id_core_trim_sync\[0\].applied_u_ff u_dll_u_ring_dstage\[0\].id_core_delaymux1_u_a1/B
+ u_dll_u_ring_dstage\[0\].id_core_delayinv1_u_inv/Y u_dll_u_ring_dstage\[0\].id_core_trim_sync\[0\].meta_u_ff/Q
+ u_dll_u_ring_dstage\[0\].id_core_trim_reset_inv_u_inv/Y VPWR VGND sg13cmos5l_dfrbpq_1
Xu_dll_u_control__1815_ u_dll_u_control__2234_/D u_dll_u_control__1813_/A u_dll_u_control__1813_/B
+ u_dll_u_control__1814_/Y VPWR VGND sg13cmos5l_a21oi_1
Xu_dll_u_control__1746_ u_dll_u_control__1783_/A u_dll_u_control__1746_/A u_dll_u_control__1746_/B
+ u_dll_u_control__1746_/C VPWR VGND sg13cmos5l_and3_1
Xu_dll_u_control__1677_ u_dll_u_control__1677_/Y u_dll_u_control__2129_/Q u_dll_u_control__1469_/Y
+ u_dll_u_control__1909_/A VPWR VGND sg13cmos5l_o21ai_1
XFILLER_45_67 VPWR VGND sg13cmos5l_decap_4
XFILLER_16_328 VPWR VGND sg13cmos5l_decap_8
Xu_dll_u_control__2229_ u_dll_u_control__2229_/Q clkload3/A u_dll_u_control__2229_/D
+ u_dll_u_control__2086_/Y VPWR VGND sg13cmos5l_dfrbpq_1
XFILLER_34_158 VPWR VGND sg13cmos5l_fill_2
XFILLER_30_353 VPWR VGND sg13cmos5l_fill_2
XFILLER_15_394 VPWR VGND sg13cmos5l_decap_8
Xu_dll_u_control__1600_ u_dll_u_control__1624_/B u_dll_u_control__1619_/B u_dll_u_control__1552_/Y
+ u_dll_u_control__1599_/Y VPWR VGND sg13cmos5l_o21ai_1
Xu_dll_u_control__1531_ u_dll_u_control__1735_/B u_dll_u_control__1531_/A u_dll_u_control__1531_/B
+ u_dll_u_control__1744_/B VPWR VGND sg13cmos5l_nor3_1
XFILLER_32_0 VPWR VGND sg13cmos5l_fill_2
Xu_dll_u_control__1462_ u_dll_u_control__2167_/D u_dll_u_control__1462_/A u_dll_u_control__1462_/B
+ VPWR VGND sg13cmos5l_nor2_1
Xu_dll_u_control__1393_ u_dll_u_control__2190_/D u_dll_u_control__1345_/B u_dll_u_control__1397_/A2
+ u_dll_u_control__1392_/Y VPWR VGND sg13cmos5l_o21ai_1
Xu_dll_u_ring_dstage\[6\].id_core_delayinv1_u_inv u_dll_u_ring_dstage\[6\].id_core_delayinv1_u_inv/Y
+ u_dll_u_ring_dstage\[6\].id_core_delayinv1_u_inv/A VPWR VGND sg13cmos5l_inv_2
XFILLER_40_139 VPWR VGND sg13cmos5l_fill_1
XFILLER_21_353 VPWR VGND sg13cmos5l_fill_2
Xu_dll_u_control__2014_ u_dll_u_control__2014_/Y u_dll_u_control__2042_/A VPWR VGND
+ sg13cmos5l_inv_1
Xu_dll_u_control__1729_ u_dll_u_control__1729_/Y u_dll_u_control__2321_/Q u_dll_u_control__1727_/B
+ u_dll_u_control__1728_/Y VPWR VGND sg13cmos5l_o21ai_1
Xu_dll_u_ring_iss_core_delaymux1_u_sel u_dll_u_ring_iss_core_delaymux1_u_a0/B u_dll_u_ring_iss_core_delaymux1_u_a1/B
+ VPWR VGND sg13cmos5l_inv_1
XFILLER_8_324 VPWR VGND sg13cmos5l_fill_2
XFILLER_12_397 VPWR VGND sg13cmos5l_decap_8
Xu_dll_u_control__1514_ u_dll_u_control__1515_/B u_dll_u_control__2227_/Q u_dll_u_control__1532_/B
+ VPWR VGND sg13cmos5l_nand2b_1
Xu_dll_u_control__1445_ u_dll_u_control__1460_/A u_dll_u_control__2168_/Q u_dll_u_control__2167_/Q
+ u_dll_u_control__1445_/C VPWR VGND sg13cmos5l_and3_1
Xu_dll_u_control__1376_ u_dll_u_control__1377_/C u_dll_u_control__2196_/Q u_dll_u_control__1382_/A
+ VPWR VGND sg13cmos5l_nor2b_1
XFILLER_4_393 VPWR VGND sg13cmos5l_decap_8
Xclkbuf_5_6__f_u_dll\_controller_ref_clk u_dll_u_control__2235_/CLK clkbuf_4_3_0_u_dll\_controller_ref_clk/X
+ VPWR VGND sg13cmos5l_buf_8
Xu_dll_u_control__1161_ u_dll_u_control__1161_/Y u_dll_u_control__1161_/A u_dll_u_control__1161_/B
+ u_dll_u_control__1161_/C VPWR VGND sg13cmos5l_nor3_1
Xu_dll_u_control__1230_ u_dll_u_control__1230_/Y u_dll_u_control__1230_/A u_dll_u_control__1246_/B
+ VPWR VGND sg13cmos5l_nand2_1
Xu_dll_u_control__1092_ u_dll_u_control__1092_/Y u_dll_u_control__1909_/A VPWR VGND
+ sg13cmos5l_inv_1
Xu_dll_u_control__1994_ u_dll_u_control__1994_/Y u_dll_u_control__1996_/A VPWR VGND
+ sg13cmos5l_inv_1
Xu_dll_u_control__1428_ u_dll_u_control__1444_/B u_dll_u_control__2179_/Q u_dll_u_control__2173_/Q
+ u_dll_u_control__1445_/C VPWR VGND sg13cmos5l_and3_1
Xu_dll_u_control__1359_ u_dll_u_control__1361_/B u_dll_u_control__1354_/B u_dll_u_control__1358_/Y
+ u_dll_u_control__1371_/A VPWR VGND sg13cmos5l_a21oi_1
XFILLER_49_323 VPWR VGND sg13cmos5l_decap_8
Xu_dll_u_div1__111_ u_dll_u_div1__111_/Q u_dll_u_div1__115_/CLK uio_in[2] u_dll_u_div1_fanout60/X
+ VPWR VGND sg13cmos5l_dfrbpq_1
XFILLER_1_374 VPWR VGND sg13cmos5l_decap_8
Xu_dll_u_ring_iss_core_reset_inv_u_inv u_dll_u_ring_iss_core_reset_inv_u_inv/Y u_dll_u_ring_reset_buffer_u_buf/X
+ VPWR VGND sg13cmos5l_inv_1
XFILLER_32_223 VPWR VGND sg13cmos5l_fill_1
Xu_dll_u_ring_dstage\[9\].id_core_delaymux1_u_sel u_dll_u_ring_dstage\[9\].id_core_delaymux1_u_a0/B
+ u_dll_u_ring_dstage\[9\].id_core_delaymux1_u_a1/B VPWR VGND sg13cmos5l_inv_1
Xu_dll_u_control__2262_ u_dll_u_control__2262_/Q u_dll_u_control__2285_/CLK u_dll_u_control__2262_/D
+ u_dll_u_control__2119_/Y VPWR VGND sg13cmos5l_dfrbpq_1
Xu_dll_u_control__1144_ u_dll_u_control__1152_/S u_dll_u_control__2141_/Q u_dll_u_control__1183_/B
+ u_dll_u_control__1183_/C VPWR VGND sg13cmos5l_nor3_1
Xu_dll_u_control__1213_ u_dll_u_control__1213_/Y u_dll_u_control__1213_/A VPWR VGND
+ sg13cmos5l_inv_1
Xu_dll_u_control__2193_ u_dll_u_control__2193_/Q u_dll_u_control__2314_/CLK u_dll_u_control__2193_/D
+ u_dll_u_control__2050_/Y VPWR VGND sg13cmos5l_dfrbpq_1
Xu_dll_u_control__1075_ u_dll_u_control__1075_/Y u_dll_u_control__2262_/Q VPWR VGND
+ sg13cmos5l_inv_1
Xu_dll_u_control__1977_ u_dll_u_control__1977_/Y u_dll_u_control__2099_/A VPWR VGND
+ sg13cmos5l_inv_1
Xu_dll_u_div0__060_ u_dll_u_div0__072_/B u_dll_u_div0__109_/Q u_dll_u_div0__108_/Q
+ u_dll_u_div0__106_/Q u_dll_u_div0__060_/D VPWR VGND sg13cmos5l_nor4_1
XFILLER_3_7 VPWR VGND sg13cmos5l_decap_8
XFILLER_14_212 VPWR VGND sg13cmos5l_decap_4
Xu_dll_u_ring_dstage\[0\].id_core_secondary_inv_u_inv u_dll_u_ring_dstage\[0\].id_core_short_decode_u_and/B
+ u_dll_u_ring_dstage\[0\].id_core_long_gate_u_nand/B VPWR VGND sg13cmos5l_inv_1
XFILLER_36_7 VPWR VGND sg13cmos5l_decap_8
Xu_dll_u_ring_dstage\[0\].id_core_delaymux1_u_a0 u_dll_u_ring_dstage\[0\].id_core_delaymux1_u_a0/Y
+ u_dll_u_ring_dstage\[0\].id_core_delaymux1_u_a0/A u_dll_u_ring_dstage\[0\].id_core_delaymux1_u_a0/B
+ VPWR VGND sg13cmos5l_nand2_2
XFILLER_49_197 VPWR VGND sg13cmos5l_decap_8
XFILLER_49_153 VPWR VGND sg13cmos5l_fill_2
XFILLER_49_142 VPWR VGND sg13cmos5l_decap_8
XFILLER_37_359 VPWR VGND sg13cmos5l_fill_2
XFILLER_45_370 VPWR VGND sg13cmos5l_decap_8
Xu_dll_u_ring_trim_reset_buffers\[0\].u_buffer_u_buf u_dll_u_ring_trim_reset_buffers\[0\].u_buffer_u_buf/X
+ u_dll_u_ring_reset_buffer_u_buf/X VPWR VGND sg13cmos5l_buf_4
Xu_dll_u_control__1900_ u_dll_u_control__1901_/D u_dll_u_control__2178_/Q u_dll_u_control__2177_/Q
+ u_dll_u_control__2176_/Q u_dll_u_control__2173_/Q VPWR VGND sg13cmos5l_and4_1
XFILLER_9_271 VPWR VGND sg13cmos5l_decap_8
Xu_dll_u_ring_dstage\[5\].id_core_long_gate_u_nand u_dll_u_ring_dstage\[5\].id_core_long_gate_u_nand/Y
+ u_dll_u_ring_dstage\[5\].id_core_long_gate_u_nand/A u_dll_u_ring_dstage\[5\].id_core_long_gate_u_nand/B
+ VPWR VGND sg13cmos5l_nand2_2
Xu_dll_u_control__1831_ u_dll_u_control__1855_/A u_dll_u_control__1841_/D u_dll_u_control__1838_/B
+ u_dll_u_control__1851_/B VPWR VGND sg13cmos5l_o21ai_1
Xu_dll_u_control__1762_ u_dll_u_control__1763_/D u_dll_u_control__1785_/A u_dll_u_control__1764_/A
+ u_dll_u_control__1764_/B VPWR VGND sg13cmos5l_and3_1
Xu_dll_u_control__1693_ u_dll_u_control__2221_/D u_dll_u_control__1741_/B u_dll_u_control__1693_/B
+ VPWR VGND sg13cmos5l_nor2_1
Xu_dll_u_control__2245_ u_dll_u_control__2245_/Q u_dll_u_control__2245_/CLK u_dll_u_control__2245_/D
+ u_dll_u_control__2102_/Y VPWR VGND sg13cmos5l_dfrbpq_1
XFILLER_36_370 VPWR VGND sg13cmos5l_decap_8
XFILLER_28_337 VPWR VGND sg13cmos5l_fill_1
Xu_dll_u_control__2314_ u_dll_u_control__2314_/Q u_dll_u_control__2314_/CLK u_dll_u_control__2314_/D
+ u_dll_u_control__1974_/Y VPWR VGND sg13cmos5l_dfrbpq_1
Xu_dll_u_control__1127_ u_dll_u_control__1884_/C u_dll_u_control__1127_/A VPWR VGND
+ sg13cmos5l_inv_1
Xu_dll_u_div0__112_ u_dll_u_div0__112_/Q u_dll_u_div0__115_/CLK u_dll_u_div0__112_/D
+ u_dll_u_div0_fanout59/X VPWR VGND sg13cmos5l_dfrbpq_1
Xu_dll_u_control__2176_ u_dll_u_control__2176_/Q u_dll_u_control__2301_/CLK u_dll_u_control__2176_/D
+ u_dll_u_control__2033_/Y VPWR VGND sg13cmos5l_dfrbpq_1
XFILLER_11_226 VPWR VGND sg13cmos5l_decap_8
Xclkload2 clkload2/Y clkload2/A VPWR VGND sg13cmos5l_inv_1
Xclkbuf_5_17__f_u_dll\_controller_ref_clk clkload4/A clkbuf_4_8_0_u_dll\_controller_ref_clk/X
+ VPWR VGND sg13cmos5l_buf_8
XFILLER_19_326 VPWR VGND sg13cmos5l_fill_1
XFILLER_19_337 VPWR VGND sg13cmos5l_fill_2
XFILLER_42_362 VPWR VGND sg13cmos5l_decap_4
XFILLER_6_252 VPWR VGND sg13cmos5l_decap_8
Xu_dll_u_ring_dstage\[11\].id_core_delaymux1_u_merge u_dll_u_ring_dstage\[11\].id_core_long_gate_u_nand/A
+ u_dll_u_ring_dstage\[11\].id_core_delaymux1_u_a0/Y u_dll_u_ring_dstage\[11\].id_core_delaymux1_u_a1/Y
+ VPWR VGND sg13cmos5l_nand2_2
XFILLER_33_395 VPWR VGND sg13cmos5l_decap_8
XFILLER_33_373 VPWR VGND sg13cmos5l_fill_1
XFILLER_33_351 VPWR VGND sg13cmos5l_decap_4
Xu_dll_u_control__2030_ u_dll_u_control__2030_/Y u_dll_fanout80/X VPWR VGND sg13cmos5l_inv_1
Xu_dll_u_control__1814_ u_dll_u_control__1814_/Y u_dll_u_control__1814_/A u_dll_u_control__1816_/B
+ VPWR VGND sg13cmos5l_nand2_1
Xu_dll_u_control__1745_ u_dll_u_control__1746_/C u_dll_u_control__1537_/B u_dll_u_control__1531_/B
+ u_dll_u_control__1772_/A u_dll_u_control__1752_/A u_dll_u_control__1531_/A VPWR
+ VGND sg13cmos5l_a221oi_1
Xu_dll_u_ring_dstage\[9\].id_core_reset_inv_u_inv u_dll_u_ring_dstage\[9\].id_core_reset_inv_u_inv/Y
+ u_dll_u_ring_dstage\[9\].id_const0_u_lo/L_LO VPWR VGND sg13cmos5l_inv_1
Xu_dll_u_control__1676_ u_dll_u_control__2130_/D u_dll_u_control__1909_/A u_dll_u_control__2310_/Q
+ VPWR VGND sg13cmos5l_and2_1
XFILLER_45_57 VPWR VGND sg13cmos5l_fill_2
XFILLER_43_115 VPWR VGND sg13cmos5l_fill_1
XFILLER_43_104 VPWR VGND sg13cmos5l_decap_8
XFILLER_16_318 VPWR VGND sg13cmos5l_fill_2
Xu_dll_u_control__2159_ u_dll_u_control__2159_/Q u_dll_u_control__2161_/CLK u_dll_u_control__2159_/D
+ u_dll_u_control__2016_/Y VPWR VGND sg13cmos5l_dfrbpq_1
Xu_dll_u_control__2228_ u_dll_u_control__2228_/Q clkload2/A u_dll_u_control__2228_/D
+ u_dll_u_control__2085_/Y VPWR VGND sg13cmos5l_dfrbpq_1
XFILLER_3_233 VPWR VGND sg13cmos5l_fill_1
XFILLER_34_137 VPWR VGND sg13cmos5l_decap_8
XFILLER_30_365 VPWR VGND sg13cmos5l_decap_4
Xu_dll_u_control__1530_ u_dll_u_control__1744_/B u_dll_u_control__2230_/Q u_dll_u_control__1530_/B
+ VPWR VGND sg13cmos5l_xnor2_1
Xu_dll_u_control__1461_ u_dll_u_control__1462_/B u_dll_u_control__2167_/Q u_dll_u_control__1463_/B
+ VPWR VGND sg13cmos5l_nor2_1
XFILLER_40_118 VPWR VGND sg13cmos5l_decap_4
Xu_dll_u_ring_dstage\[10\].id_core_slow_isolation_u_buf u_dll_u_ring_dstage\[10\].id_core_delaymux1_u_a1/A
+ u_dll_u_ring_dstage\[9\].id_core_reset_gate_u_aoi/Y VPWR VGND sg13cmos5l_buf_2
Xu_dll_u_control__1392_ u_dll_u_control__1392_/Y u_dll_u_control__2190_/Q u_dll_u_control__1392_/B
+ VPWR VGND sg13cmos5l_nand2_1
Xu_dll_u_control__2013_ u_dll_u_control__2013_/Y u_dll_u_control__2042_/A VPWR VGND
+ sg13cmos5l_inv_1
XFILLER_25_148 VPWR VGND sg13cmos5l_fill_1
XFILLER_21_365 VPWR VGND sg13cmos5l_decap_4
Xu_dll_u_control__1728_ u_dll_u_control__1728_/Y u_dll_u_control__1728_/A u_dll_u_control__1728_/B
+ VPWR VGND sg13cmos5l_nand2_1
Xu_dll_u_ring_dstage\[10\].id_core_secondary_inv_u_inv u_dll_u_ring_dstage\[10\].id_core_short_decode_u_and/B
+ u_dll_u_ring_dstage\[10\].id_core_long_gate_u_nand/B VPWR VGND sg13cmos5l_inv_1
Xu_dll_u_control__1659_ u_dll_u_control__1659_/Y u_dll_u_control__1661_/A u_dll_u_control__1659_/B
+ u_dll_u_control__1673_/C VPWR VGND sg13cmos5l_nor3_1
Xu_dll_u_ring_dstage\[8\].id_core_delaybuf1_u_buf u_dll_u_ring_dstage\[8\].id_core_delayinv1_u_inv/A
+ u_dll_u_ring_dstage\[8\].id_core_delaymux1_u_a1/A VPWR VGND sg13cmos5l_buf_1
XFILLER_15_170 VPWR VGND sg13cmos5l_fill_1
Xu_dll_u_control__1513_ u_dll_u_control__1532_/B u_dll_u_control__1541_/B u_dll_u_control__1513_/B
+ VPWR VGND sg13cmos5l_and2_1
Xu_dll_u_control__1444_ u_dll_u_control__2173_/D u_dll_u_control__1456_/A u_dll_u_control__1444_/B
+ u_dll_u_control__1444_/C VPWR VGND sg13cmos5l_nor3_1
Xu_dll_u_control__1375_ u_dll_u_control__1377_/B u_dll_u_control__1370_/B u_dll_u_control__1374_/X
+ u_dll_u_control__1382_/A VPWR VGND sg13cmos5l_a21oi_1
XFILLER_21_162 VPWR VGND sg13cmos5l_fill_2
Xu_dll_u_ring_dstage\[8\].id_core_trim_sync\[1\].meta_u_ff u_dll_u_ring_dstage\[8\].id_core_trim_sync\[1\].meta_u_ff/Q
+ u_dll_u_ring_dstage\[8\].id_core_delayinv1_u_inv/Y u_dll_u_control__1070_/Y u_dll_u_ring_dstage\[8\].id_core_trim_reset_inv_u_inv/Y
+ VPWR VGND sg13cmos5l_dfrbpq_1
XFILLER_16_70 VPWR VGND sg13cmos5l_fill_1
XFILLER_8_155 VPWR VGND sg13cmos5l_fill_2
XFILLER_16_92 VPWR VGND sg13cmos5l_fill_1
Xu_dll_u_div1_u_odd_extend_u_or u_dll_u_div1_u_parity_mux_u_a1/A u_dll_u_div1__100_/D
+ u_dll_u_div1__100_/Q VPWR VGND sg13cmos5l_or2_1
XFILLER_4_372 VPWR VGND sg13cmos5l_decap_8
Xu_dll_u_control__1160_ u_dll_u_control__1161_/C u_dll_u_control__2282_/Q u_dll_u_control__1160_/B
+ VPWR VGND sg13cmos5l_nor2_1
XFILLER_35_254 VPWR VGND sg13cmos5l_fill_2
Xu_dll_u_control__1091_ u_dll_u_control__1091_/Y u_dll_u_control__2318_/Q VPWR VGND
+ sg13cmos5l_inv_1
Xu_dll_u_control__1993_ u_dll_u_control__1993_/Y u_dll_u_control__1996_/A VPWR VGND
+ sg13cmos5l_inv_1
XFILLER_41_202 VPWR VGND sg13cmos5l_decap_8
Xu_dll_u_control__1427_ u_dll_u_control__2179_/D u_dll_u_control__1427_/A VPWR VGND
+ sg13cmos5l_inv_1
Xu_dll_u_control__1358_ u_dll_u_control__1358_/Y u_dll_u_control__2200_/Q u_dll_u_control__1358_/B
+ VPWR VGND sg13cmos5l_nand2b_1
XFILLER_41_268 VPWR VGND sg13cmos5l_fill_2
Xu_dll_u_control__1289_ u_dll_u_control__1699_/B u_dll_u_control__2211_/Q u_dll_u_control__2210_/Q
+ u_dll_u_control__2212_/Q VPWR VGND sg13cmos5l_and3_1
Xclkbuf_4_14__f_u_dll\_controller_ring_clk u_dll_u_control__2296_/CLK clkbuf_3_7_0_u_dll\_controller_ring_clk/X
+ VPWR VGND sg13cmos5l_buf_8
Xu_dll_u_div1__110_ u_dll_u_div1__110_/Q u_dll_u_div1__110_/CLK u_dll_u_div1__115_/Q
+ u_dll_u_div1_fanout60/X VPWR VGND sg13cmos5l_dfrbpq_1
XFILLER_32_202 VPWR VGND sg13cmos5l_fill_2
Xu_dll_u_control__1212_ u_dll_u_control__1213_/A u_dll_u_control__1227_/B u_dll_u_control__1211_/Y
+ VPWR VGND sg13cmos5l_nor2b_1
Xu_dll_u_control__2192_ u_dll_u_control__2192_/Q u_dll_u_control__2315_/CLK u_dll_u_control__2192_/D
+ u_dll_u_control__2049_/Y VPWR VGND sg13cmos5l_dfrbpq_1
Xu_dll_u_control__2261_ u_dll_u_control__2261_/Q clkload4/A u_dll_u_control__2261_/D
+ u_dll_u_control__2118_/Y VPWR VGND sg13cmos5l_dfrbpq_1
Xu_dll_u_control__1143_ u_dll_u_control__1143_/Y u_dll_u_control__1183_/B u_dll_u_control__1183_/C
+ VPWR VGND sg13cmos5l_nor2_1
Xu_dll_u_control__1074_ u_dll_u_control__1074_/Y u_dll_u_control__2263_/Q VPWR VGND
+ sg13cmos5l_inv_1
Xu_dll_u_control__1976_ u_dll_u_control__1976_/Y u_dll_u_control__2099_/A VPWR VGND
+ sg13cmos5l_inv_1
XFILLER_46_338 VPWR VGND sg13cmos5l_fill_1
Xu_dll_u_ref_buffer_u_buf u_dll_u_ref_buffer_u_buf/X clk VPWR VGND sg13cmos5l_buf_2
Xu_dll_u_ring_dstage\[0\].id_core_delaymux1_u_a1 u_dll_u_ring_dstage\[0\].id_core_delaymux1_u_a1/Y
+ u_dll_u_ring_dstage\[0\].id_core_delaymux1_u_a1/A u_dll_u_ring_dstage\[0\].id_core_delaymux1_u_a1/B
+ VPWR VGND sg13cmos5l_nand2_2
XFILLER_49_176 VPWR VGND sg13cmos5l_fill_2
XFILLER_37_349 VPWR VGND sg13cmos5l_fill_2
XFILLER_9_261 VPWR VGND sg13cmos5l_fill_2
Xu_dll_u_control__1761_ u_dll_u_control__1763_/C u_dll_u_control__1785_/A u_dll_u_control__1764_/B
+ u_dll_u_control__1764_/A VPWR VGND sg13cmos5l_a21oi_1
Xu_dll_u_control__1830_ u_dll_u_control__1838_/B u_dll_u_control__1834_/A u_dll_u_control__1833_/C
+ u_dll_u_control__1834_/C VPWR VGND sg13cmos5l_nand3_1
XFILLER_28_316 VPWR VGND sg13cmos5l_fill_1
Xu_dll_u_control__1692_ u_dll_u_control__2223_/D u_dll_u_control__2222_/Q u_dll_u_control__1716_/C
+ VPWR VGND sg13cmos5l_and2_1
Xu_dll_u_control__2244_ u_dll_u_control__2244_/Q u_dll_u_control__2275_/CLK u_dll_u_control__2244_/D
+ u_dll_u_control__2101_/Y VPWR VGND sg13cmos5l_dfrbpq_1
XFILLER_34_15 VPWR VGND sg13cmos5l_fill_1
Xu_dll_u_control__2175_ u_dll_u_control__2175_/Q u_dll_u_control__2296_/CLK u_dll_u_control__2175_/D
+ u_dll_u_control__2032_/Y VPWR VGND sg13cmos5l_dfrbpq_1
Xu_dll_u_control__2313_ u_dll_u_control__2313_/Q clkload8/A u_dll_u_control__2313_/D
+ u_dll_u_control__1973_/Y VPWR VGND sg13cmos5l_dfrbpq_1
Xu_dll_u_control__1126_ u_dll_u_control__1127_/A u_dll_u_control__2139_/Q u_dll_u_control__2279_/Q
+ VPWR VGND sg13cmos5l_xor2_1
Xu_dll_u_div0__111_ u_dll_u_div0__111_/Q u_dll_u_div0__115_/CLK ui_in[5] u_dll_u_div0_fanout59/X
+ VPWR VGND sg13cmos5l_dfrbpq_1
XFILLER_11_249 VPWR VGND sg13cmos5l_decap_8
Xclkload3 clkload3/Y clkload3/A VPWR VGND sg13cmos5l_inv_1
Xu_dll_u_control__1959_ u_dll_u_control__1959_/Y u_dll_u_control__2035_/A VPWR VGND
+ sg13cmos5l_inv_1
Xu_dll_u_ring_dstage\[11\].id_core_merge_gate_u_nand u_dll_u_ring_dstage\[11\].id_core_reset_gate_u_aoi/B1
+ u_dll_u_ring_dstage\[11\].id_core_short_gate_u_nand/Y u_dll_u_ring_dstage\[11\].id_core_long_gate_u_nand/Y
+ u_dll_u_ring_dstage\[11\].id_core_reset_inv_u_inv/Y VPWR VGND sg13cmos5l_nand3_1
XFILLER_42_396 VPWR VGND sg13cmos5l_decap_8
Xu_dll_u_ring_dstage\[9\].id_core_reset_gate_u_aoi u_dll_u_ring_dstage\[9\].id_core_reset_gate_u_aoi/Y
+ u_dll_u_ring_dstage\[8\].id_core_reset_gate_u_aoi/Y u_dll_u_ring_dstage\[9\].id_core_reset_gate_u_aoi/A2
+ u_dll_u_ring_dstage\[9\].id_core_reset_gate_u_aoi/B1 VPWR VGND sg13cmos5l_a21oi_2
XFILLER_6_231 VPWR VGND sg13cmos5l_decap_8
XFILLER_10_282 VPWR VGND sg13cmos5l_fill_1
Xclkbuf_5_23__f_u_dll\_controller_ref_clk u_dll_u_control__2285_/CLK clkbuf_4_11_0_u_dll\_controller_ref_clk/X
+ VPWR VGND sg13cmos5l_buf_8
XFILLER_37_179 VPWR VGND sg13cmos5l_decap_8
Xu_dll_u_control__1744_ u_dll_u_control__1746_/B u_dll_u_control__1299_/A u_dll_u_control__1744_/B
+ VPWR VGND sg13cmos5l_nand2b_1
XFILLER_20_17 VPWR VGND sg13cmos5l_fill_1
Xu_dll_u_control__1813_ u_dll_u_control__1816_/B u_dll_u_control__1813_/A u_dll_u_control__1813_/B
+ VPWR VGND sg13cmos5l_or2_1
Xu_dll_u_control__1675_ u_dll_u_control__2131_/D u_dll_u_control__1469_/A u_dll_u_control__1297_/B
+ u_dll_u_control__1741_/B VPWR VGND sg13cmos5l_a21oi_1
Xu_dll_u_control__1109_ u_dll_u_control__1879_/A u_dll_u_control__2136_/Q u_dll_u_control__2276_/Q
+ VPWR VGND sg13cmos5l_nand2_1
XFILLER_43_138 VPWR VGND sg13cmos5l_fill_1
Xu_dll_u_control__2158_ u_dll_u_control__2158_/Q clkload2/A u_dll_u_control__2158_/D
+ u_dll_u_control__2015_/Y VPWR VGND sg13cmos5l_dfrbpq_1
Xu_dll_u_control__2227_ u_dll_u_control__2227_/Q u_dll_u_control__2227_/CLK u_dll_u_control__2227_/D
+ u_dll_u_control__2084_/Y VPWR VGND sg13cmos5l_dfrbpq_1
Xu_dll_u_control__2089_ u_dll_u_control__2089_/Y u_dll_u_control__2090_/A VPWR VGND
+ sg13cmos5l_inv_1
Xu_dll_u_control__2318__128 u_dll_u_control__2318_/D VPWR VGND sg13cmos5l_tiehi
Xu_dll_u_control__1460_ u_dll_u_control__2168_/D u_dll_u_control__1460_/A u_dll_u_control__1460_/B
+ VPWR VGND sg13cmos5l_nor2_1
Xu_dll_u_control__1391_ u_dll_u_control__2191_/D u_dll_u_control__1341_/B u_dll_u_control__1397_/A2
+ u_dll_u_control__1390_/Y VPWR VGND sg13cmos5l_o21ai_1
XFILLER_33_193 VPWR VGND sg13cmos5l_fill_2
XFILLER_33_182 VPWR VGND sg13cmos5l_decap_4
Xu_dll_u_control__2012_ u_dll_u_control__2012_/Y u_dll_u_control__2083_/A VPWR VGND
+ sg13cmos5l_inv_1
XFILLER_21_399 VPWR VGND sg13cmos5l_fill_2
Xu_dll_u_control__1727_ u_dll_u_control__1728_/B u_dll_u_control__2321_/Q u_dll_u_control__1727_/B
+ VPWR VGND sg13cmos5l_nand2_1
Xu_dll_u_ring_dstage\[8\].id_core_trim_sync\[0\].meta_u_ff u_dll_u_ring_dstage\[8\].id_core_trim_sync\[0\].meta_u_ff/Q
+ u_dll_u_ring_dstage\[8\].id_core_delayinv1_u_inv/Y u_dll_u_control__2254_/Q u_dll_u_ring_dstage\[8\].id_core_trim_reset_inv_u_inv/Y
+ VPWR VGND sg13cmos5l_dfrbpq_1
Xu_dll_u_control__1658_ u_dll_u_control__2140_/D u_dll_u_control__1571_/A u_dll_u_control__1653_/A
+ u_dll_u_control__1653_/Y u_dll_u_control__1657_/Y VPWR VGND sg13cmos5l_a22oi_1
XFILLER_44_403 VPWR VGND sg13cmos5l_fill_1
Xu_dll_u_control__1589_ u_dll_u_control__1632_/A u_dll_u_control__2136_/Q u_dll_u_control__2242_/Q
+ u_dll_u_control__1588_/Y VPWR VGND sg13cmos5l_a21oi_1
Xu_dll_u_ring_dstage\[3\].id_core_trim_sync\[1\].meta_u_ff u_dll_u_ring_dstage\[3\].id_core_trim_sync\[1\].meta_u_ff/Q
+ u_dll_u_ring_dstage\[3\].id_core_delayinv1_u_inv/Y u_dll_u_control__1075_/Y u_dll_u_ring_dstage\[3\].id_core_trim_reset_inv_u_inv/Y
+ VPWR VGND sg13cmos5l_dfrbpq_1
XFILLER_8_304 VPWR VGND sg13cmos5l_decap_4
XFILLER_21_71 VPWR VGND sg13cmos5l_fill_1
XFILLER_35_403 VPWR VGND sg13cmos5l_fill_1
Xu_dll_u_ring_dstage\[3\].id_const0_u_hi u_dll_u_ring_dstage\[3\].id_const0_u_hi/L_HI
+ VPWR VGND sg13cmos5l_tiehi
XFILLER_30_163 VPWR VGND sg13cmos5l_decap_8
Xu_dll_u_control__1512_ u_dll_u_control__1513_/B u_dll_u_control__1526_/A u_dll_u_control__2226_/Q
+ VPWR VGND sg13cmos5l_nand2_1
XFILLER_38_285 VPWR VGND sg13cmos5l_decap_4
Xu_dll_u_control__1443_ u_dll_u_control__1444_/C u_dll_u_control__2179_/Q u_dll_u_control__1445_/C
+ u_dll_u_control__2173_/Q VPWR VGND sg13cmos5l_a21oi_1
Xu_dll_u_control__1374_ u_dll_u_control__1374_/X u_dll_u_control__2195_/Q u_dll_u_control__2194_/Q
+ u_dll_u_control__2196_/Q VPWR VGND sg13cmos5l_a21o_1
Xu_dll_u_ring_iss_core_slow_isolation_u_buf u_dll_u_ring_iss_core_delaymux1_u_a1/A
+ u_dll_u_ring_iss_core_short_gate_u_nand/A VPWR VGND sg13cmos5l_buf_2
XFILLER_17_403 VPWR VGND sg13cmos5l_fill_1
XFILLER_12_163 VPWR VGND sg13cmos5l_fill_2
XFILLER_4_351 VPWR VGND sg13cmos5l_decap_8
Xu_dll_u_control__1090_ u_dll_u_control__1899_/A u_dll_u_control__1896_/A VPWR VGND
+ sg13cmos5l_inv_1
Xu_dll_u_control__1992_ u_dll_u_control__1992_/Y u_dll_u_control__1996_/A VPWR VGND
+ sg13cmos5l_inv_1
XFILLER_41_247 VPWR VGND sg13cmos5l_fill_1
Xu_dll_u_control__1426_ u_dll_u_control__1427_/A u_dll_u_control__2179_/Q u_dll_u_control__1421_/Y
+ u_dll_u_control__1901_/C u_dll_u_control__1463_/B VPWR VGND sg13cmos5l_a22oi_1
Xu_dll_u_ring_dstage\[10\].id_core_fast_decode_u_nor u_dll_u_ring_dstage\[10\].id_core_reset_gate_u_aoi/A2
+ u_dll_u_ring_dstage\[10\].id_core_delaymux1_u_a1/B u_dll_u_ring_dstage\[10\].id_core_long_gate_u_nand/B
+ VPWR VGND sg13cmos5l_nor2_2
Xu_dll_u_control__1357_ u_dll_u_control__1358_/B u_dll_u_control__2199_/Q u_dll_u_control__2198_/Q
+ u_dll_u_control__1366_/B VPWR VGND sg13cmos5l_nand3_1
Xu_dll_u_control__1288_ u_dll_u_control__2259_/D u_dll_u_control__1859_/A u_dll_u_control__1287_/Y
+ u_dll_u_control__1285_/A VPWR VGND sg13cmos5l_a21oi_1
XFILLER_49_314 VPWR VGND sg13cmos5l_fill_1
XFILLER_49_369 VPWR VGND sg13cmos5l_decap_8
XFILLER_32_247 VPWR VGND sg13cmos5l_fill_1
Xu_dll_fanout100 u_dll__29_/B u_dll_fanout100/A VPWR VGND sg13cmos5l_buf_1
XFILLER_48_391 VPWR VGND sg13cmos5l_decap_8
Xu_dll_u_control__1142_ u_dll_u_control__1183_/C u_dll_u_control__1571_/A u_dll_u_control__1142_/B
+ u_dll_u_control__1142_/C VPWR VGND sg13cmos5l_nor3_1
Xu_dll_u_control__1211_ u_dll_u_control__1211_/Y u_dll_u_control__2283_/Q u_dll_u_control__1241_/A
+ u_dll_u_control__2284_/Q VPWR VGND sg13cmos5l_o21ai_1
Xu_dll_u_control__2260_ u_dll_u_control__2260_/Q u_dll_u_control__2280_/CLK u_dll_u_control__2260_/D
+ u_dll_u_control__2117_/Y VPWR VGND sg13cmos5l_dfrbpq_1
Xu_dll_u_control__2191_ u_dll_u_control__2191_/Q u_dll_u_control__2314_/CLK u_dll_u_control__2191_/D
+ u_dll_u_control__2048_/Y VPWR VGND sg13cmos5l_dfrbpq_1
Xu_dll_u_control__1073_ u_dll_u_control__1073_/Y u_dll_u_control__2264_/Q VPWR VGND
+ sg13cmos5l_inv_1
XFILLER_23_39 VPWR VGND sg13cmos5l_fill_1
Xu_dll_u_control__1975_ u_dll_u_control__1975_/Y u_dll_u_control__2064_/A VPWR VGND
+ sg13cmos5l_inv_1
Xu_dll_u_ring_dstage\[2\].id_core_short_decode_u_and u_dll_u_ring_dstage\[2\].id_core_short_gate_u_nand/B
+ u_dll_u_ring_dstage\[2\].id_core_delaymux1_u_a1/B u_dll_u_ring_dstage\[2\].id_core_short_decode_u_and/B
+ VPWR VGND sg13cmos5l_and2_2
Xu_dll_u_control__1409_ u_dll_u_control__2182_/D u_dll_u_control__1381_/B u_dll_u_control__1386_/C
+ u_dll_u_control__1408_/Y VPWR VGND sg13cmos5l_o21ai_1
XFILLER_6_402 VPWR VGND sg13cmos5l_fill_2
Xu_dll_u_ring_dstage\[8\].id_const0_u_hi u_dll_u_ring_dstage\[8\].id_const0_u_hi/L_HI
+ VPWR VGND sg13cmos5l_tiehi
XFILLER_1_173 VPWR VGND sg13cmos5l_fill_2
XFILLER_9_240 VPWR VGND sg13cmos5l_fill_1
Xu_dll_u_control__1760_ u_dll_u_control__1764_/B u_dll_u_control__1760_/A u_dll_u_control__1760_/B
+ VPWR VGND sg13cmos5l_nand2_1
Xu_dll_u_control__1691_ u_dll_u_control__2222_/D u_dll_u_control__2221_/Q u_dll_u_control__1716_/C
+ VPWR VGND sg13cmos5l_and2_1
Xu_dll_u_control__2312_ u_dll_u_control__2312_/Q u_dll_u_control__2312_/CLK u_dll_u_control__2312_/D
+ u_dll_u_control__1972_/Y VPWR VGND sg13cmos5l_dfrbpq_1
Xu_dll_u_control__1125_ u_dll_u_control__1884_/B u_dll_u_control__1881_/A u_dll_u_control__1881_/B
+ u_dll_u_control__1881_/C VPWR VGND sg13cmos5l_o21ai_1
Xu_dll_u_control__2243_ u_dll_u_control__2243_/Q u_dll_u_control__2245_/CLK u_dll_u_control__2243_/D
+ u_dll_u_control__2100_/Y VPWR VGND sg13cmos5l_dfrbpq_1
Xu_dll_u_control__2174_ u_dll_u_control__2174_/Q u_dll_u_control__2301_/CLK u_dll_u_control__2174_/D
+ u_dll_u_control__2031_/Y VPWR VGND sg13cmos5l_dfrbpq_1
Xu_dll_u_div0__110_ u_dll_u_div0__110_/Q u_dll_u_div0__110_/CLK u_dll_u_div0__115_/Q
+ u_dll_u_div0_fanout59/X VPWR VGND sg13cmos5l_dfrbpq_1
Xclkload4 clkload4/Y clkload4/A VPWR VGND sg13cmos5l_inv_1
Xu_dll_u_control__1958_ u_dll_u_control__1958_/Y u_dll_u_control__2023_/A VPWR VGND
+ sg13cmos5l_inv_1
Xu_dll_u_control__1889_ u_dll_u_control__2298_/D u_dll_u_control__1896_/A u_dll_u_control__2292_/Q
+ VPWR VGND sg13cmos5l_and2_1
XFILLER_46_147 VPWR VGND sg13cmos5l_decap_8
XFILLER_42_331 VPWR VGND sg13cmos5l_fill_2
Xu_dll_u_ring_dstage\[11\].id_core_slow_isolation_u_buf u_dll_u_ring_dstage\[11\].id_core_delaymux1_u_a1/A
+ u_dll_u_ring_dstage\[10\].id_core_reset_gate_u_aoi/Y VPWR VGND sg13cmos5l_buf_2
Xu_dll_u_ring_iss_core_delaymux1_u_merge u_dll_u_ring_iss_core_long_gate_u_nand/A
+ u_dll_u_ring_iss_core_delaymux1_u_a0/Y u_dll_u_ring_iss_core_delaymux1_u_a1/Y VPWR
+ VGND sg13cmos5l_nand2_2
XFILLER_24_71 VPWR VGND sg13cmos5l_fill_2
Xu_dll_u_ring_dstage\[10\].id_core_delayinv1_u_inv u_dll_u_ring_dstage\[10\].id_core_delayinv1_u_inv/Y
+ u_dll_u_ring_dstage\[10\].id_core_delayinv1_u_inv/A VPWR VGND sg13cmos5l_inv_2
XFILLER_37_136 VPWR VGND sg13cmos5l_decap_8
XFILLER_37_169 VPWR VGND sg13cmos5l_decap_4
XFILLER_33_331 VPWR VGND sg13cmos5l_decap_4
Xu_dll_u_control__1674_ u_dll_u_control__2132_/D u_dll_u_control__2132_/Q u_dll_u_control__1673_/A
+ u_dll_u_control__1673_/Y VPWR VGND sg13cmos5l_a21o_1
Xu_dll_u_control__1743_ u_dll_u_control__1760_/A u_dll_u_control__1742_/A u_dll_u_control__1728_/A
+ u_dll_u_control__1772_/B u_dll_u_control__2224_/Q VPWR VGND sg13cmos5l_a22oi_1
Xu_dll_u_control__1812_ u_dll_u_control__1813_/B u_dll_u_control__2163_/Q u_dll_u_control__1812_/B
+ VPWR VGND sg13cmos5l_xor2_1
Xu_dll_u_ring_dstage\[2\].id_core_delaymux1_u_sel u_dll_u_ring_dstage\[2\].id_core_delaymux1_u_a0/B
+ u_dll_u_ring_dstage\[2\].id_core_delaymux1_u_a1/B VPWR VGND sg13cmos5l_inv_1
Xu_dll_u_ring_dstage\[3\].id_core_trim_sync\[0\].meta_u_ff u_dll_u_ring_dstage\[3\].id_core_trim_sync\[0\].meta_u_ff/Q
+ u_dll_u_ring_dstage\[3\].id_core_delayinv1_u_inv/Y u_dll_u_control__2249_/Q u_dll_u_ring_dstage\[3\].id_core_trim_reset_inv_u_inv/Y
+ VPWR VGND sg13cmos5l_dfrbpq_1
Xu_dll_u_control__1108_ u_dll_u_control__1881_/A u_dll_u_control__2137_/Q u_dll_u_control__2277_/Q
+ VPWR VGND sg13cmos5l_and2_1
Xu_dll_u_control__2088_ u_dll_u_control__2088_/Y u_dll_u_control__2090_/A VPWR VGND
+ sg13cmos5l_inv_1
Xu_dll_u_control__2157_ u_dll_u_control__2157_/Q u_dll_u_control__2227_/CLK u_dll_u_control__2157_/D
+ u_dll_u_control__2014_/Y VPWR VGND sg13cmos5l_dfrbpq_1
XFILLER_24_375 VPWR VGND sg13cmos5l_fill_2
Xu_dll_u_control__2226_ u_dll_u_control__2226_/Q clkload2/A u_dll_u_control__2226_/D
+ u_dll_u_control__2083_/Y VPWR VGND sg13cmos5l_dfrbpq_1
XFILLER_10_73 VPWR VGND sg13cmos5l_fill_1
XFILLER_19_125 VPWR VGND sg13cmos5l_fill_1
XFILLER_19_147 VPWR VGND sg13cmos5l_fill_1
XFILLER_27_180 VPWR VGND sg13cmos5l_fill_2
XFILLER_30_334 VPWR VGND sg13cmos5l_decap_4
Xu_dll_u_ring_dstage\[11\].id_core_reset_gate_u_aoi u_dll_u_ring_iss_core_short_gate_u_nand/A
+ u_dll_u_ring_dstage\[10\].id_core_reset_gate_u_aoi/Y u_dll_u_ring_dstage\[11\].id_core_reset_gate_u_aoi/A2
+ u_dll_u_ring_dstage\[11\].id_core_reset_gate_u_aoi/B1 VPWR VGND sg13cmos5l_a21oi_2
XFILLER_38_401 VPWR VGND sg13cmos5l_fill_2
Xu_dll_u_control__1390_ u_dll_u_control__1390_/Y u_dll_u_control__2191_/Q u_dll_u_control__1410_/B
+ VPWR VGND sg13cmos5l_nand2_1
XFILLER_25_139 VPWR VGND sg13cmos5l_fill_1
Xu_dll_u_control__2011_ u_dll_u_control__2011_/Y u_dll_u_control__2042_/A VPWR VGND
+ sg13cmos5l_inv_1
XFILLER_48_209 VPWR VGND sg13cmos5l_fill_1
Xu_dll_u_control__1657_ u_dll_u_control__1657_/Y u_dll_u_control__1643_/C u_dll_u_control__1657_/B
+ VPWR VGND sg13cmos5l_nand2b_1
Xu_dll_u_control__1726_ u_dll_u_control__1727_/B u_dll_u_control__2320_/Q u_dll_u_control__2224_/Q
+ VPWR VGND sg13cmos5l_nand2b_1
Xu_dll_u_control__1588_ u_dll_u_control__1588_/Y u_dll_u_control__1588_/A u_dll_u_control__1588_/B
+ u_dll_u_control__1588_/C VPWR VGND sg13cmos5l_nor3_1
Xu_dll_u_control__2209_ u_dll_u_control__2209_/Q u_dll_u_control__2231_/CLK u_dll_u_control__2209_/D
+ u_dll_u_control__2066_/Y VPWR VGND sg13cmos5l_dfrbpq_1
XFILLER_12_367 VPWR VGND sg13cmos5l_fill_2
XFILLER_21_94 VPWR VGND sg13cmos5l_fill_1
XFILLER_47_297 VPWR VGND sg13cmos5l_fill_1
XFILLER_46_80 VPWR VGND sg13cmos5l_decap_4
XFILLER_30_120 VPWR VGND sg13cmos5l_fill_2
Xu_dll_u_control__1511_ u_dll_u_control__1541_/B u_dll_u_control__2224_/Q u_dll_u_control__2225_/Q
+ u_dll_u_control__1785_/A VPWR VGND sg13cmos5l_o21ai_1
Xu_dll_u_control__1442_ u_dll_u_control__2174_/D u_dll_u_control__1456_/A u_dll_u_control__1442_/B
+ u_dll_u_control__1442_/C VPWR VGND sg13cmos5l_nor3_1
Xu_dll_u_control__1373_ u_dll_u_control__2197_/D u_dll_u_control__1373_/A u_dll_u_control__1372_/Y
+ VPWR VGND sg13cmos5l_nor2b_1
Xu_dll_u_ring_dstage\[8\].id_core_delayint0_u_inv u_dll_u_ring_dstage\[8\].id_core_delaymux1_u_a0/A
+ u_dll_u_ring_dstage\[8\].id_core_delayinv1_u_inv/Y VPWR VGND sg13cmos5l_inv_1
Xu_dll_u_control__1709_ u_dll_u_control__1714_/B u_dll_u_control__2220_/Q u_dll_u_control__2218_/Q
+ VPWR VGND sg13cmos5l_nand2b_1
Xu_dll_u_ring_dstage\[2\].id_core_reset_inv_u_inv u_dll_u_ring_dstage\[2\].id_core_reset_inv_u_inv/Y
+ u_dll_u_ring_dstage\[2\].id_const0_u_lo/L_LO VPWR VGND sg13cmos5l_inv_1
Xclkbuf_4_2__f_u_dll\_controller_ring_clk u_dll_u_control__2315_/CLK clkbuf_3_1_0_u_dll\_controller_ring_clk/X
+ VPWR VGND sg13cmos5l_buf_8
XFILLER_4_330 VPWR VGND sg13cmos5l_decap_8
XFILLER_35_256 VPWR VGND sg13cmos5l_fill_1
XFILLER_35_234 VPWR VGND sg13cmos5l_decap_4
Xu_dll_u_ring_dstage\[7\].id_core_trim_sync\[1\].applied_u_ff u_dll_u_ring_dstage\[7\].id_core_long_gate_u_nand/B
+ u_dll_u_ring_dstage\[7\].id_core_delayinv1_u_inv/Y u_dll_u_ring_dstage\[7\].id_core_trim_sync\[1\].meta_u_ff/Q
+ u_dll_u_ring_dstage\[7\].id_core_trim_reset_inv_u_inv/Y VPWR VGND sg13cmos5l_dfrbpq_1
Xu_dll_u_control__1991_ u_dll_u_control__1991_/Y u_dll_u_control__2095_/A VPWR VGND
+ sg13cmos5l_inv_1
Xu_dll_u_control__1425_ u_dll_u_control__1463_/B u_dll_u_control__2301_/Q u_dll_u_control__1456_/A
+ VPWR VGND sg13cmos5l_nor2_1
Xu_dll_u_control__1287_ u_dll_u_control__1287_/Y u_dll_u_control__1834_/B u_dll_u_control__1686_/C
+ VPWR VGND sg13cmos5l_nor2_1
Xu_dll_u_control__1356_ u_dll_u_control__2201_/D u_dll_u_control__1320_/Y u_dll_u_control__1327_/Y
+ u_dll_u_control__1355_/Y VPWR VGND sg13cmos5l_a21oi_1
XFILLER_49_348 VPWR VGND sg13cmos5l_decap_8
XFILLER_49_304 VPWR VGND sg13cmos5l_fill_1
XFILLER_1_333 VPWR VGND sg13cmos5l_fill_1
XFILLER_1_388 VPWR VGND sg13cmos5l_decap_8
XFILLER_17_212 VPWR VGND sg13cmos5l_fill_2
XFILLER_43_81 VPWR VGND sg13cmos5l_fill_2
XFILLER_40_292 VPWR VGND sg13cmos5l_fill_1
XFILLER_4_42 VPWR VGND sg13cmos5l_fill_1
XFILLER_48_370 VPWR VGND sg13cmos5l_decap_8
Xu_dll_u_ring_dstage\[1\].id_core_delaybuf1_u_buf u_dll_u_ring_dstage\[1\].id_core_delayinv1_u_inv/A
+ u_dll_u_ring_dstage\[1\].id_core_delaymux1_u_a1/A VPWR VGND sg13cmos5l_buf_1
Xu_dll_u_control__1141_ u_dll_u_control__1183_/B u_dll_u_control__1106_/Y u_dll_u_control__1885_/A
+ u_dll_u_control__2140_/Q VPWR VGND sg13cmos5l_a21oi_1
Xu_dll_u_div1__099_ u_dll_u_div1__100_/D u_dll_u_div1__056_/A u_dll_u_div1__099_/D
+ u_dll_u_div1__105_/RESET_B VPWR VGND sg13cmos5l_dfrbpq_1
Xu_dll_u_control__1210_ u_dll_u_control__1227_/B u_dll_u_control__2283_/Q u_dll_u_control__2284_/Q
+ u_dll_u_control__1241_/A VPWR VGND sg13cmos5l_nor3_1
Xu_dll_u_control__1072_ u_dll_u_control__1072_/Y u_dll_u_control__2265_/Q VPWR VGND
+ sg13cmos5l_inv_1
Xu_dll_u_control__2190_ u_dll_u_control__2190_/Q u_dll_u_control__2314_/CLK u_dll_u_control__2190_/D
+ u_dll_u_control__2047_/Y VPWR VGND sg13cmos5l_dfrbpq_1
Xu_dll_u_control__1974_ u_dll_u_control__1974_/Y u_dll_u_control__2050_/A VPWR VGND
+ sg13cmos5l_inv_1
XFILLER_2_119 VPWR VGND sg13cmos5l_fill_1
Xu_dll_u_control__1408_ u_dll_u_control__1408_/Y u_dll_u_control__2182_/Q u_dll_u_control__1410_/B
+ VPWR VGND sg13cmos5l_nand2_1
Xu_dll_u_control__1339_ u_dll_u_control__1341_/B u_dll_u_control__1334_/B u_dll_u_control__1338_/Y
+ u_dll_u_control__1924_/A1 VPWR VGND sg13cmos5l_a21oi_1
XFILLER_49_134 VPWR VGND sg13cmos5l_decap_4
XFILLER_45_384 VPWR VGND sg13cmos5l_decap_8
Xclkbuf_5_28__f_u_dll\_controller_ref_clk u_dll_u_control__2214_/CLK clkbuf_4_14_0_u_dll\_controller_ref_clk/X
+ VPWR VGND sg13cmos5l_buf_8
Xu_dll_u_control__1690_ u_dll__21_/C u_dll_u_control__2166_/Q u_dll_u_control__1690_/B
+ u_dll_u_control__2209_/Q u_dll_u_control__1690_/D VPWR VGND sg13cmos5l_and4_1
Xu_dll_u_control__2242_ u_dll_u_control__2242_/Q u_dll_u_control__2245_/CLK u_dll_u_control__2242_/D
+ u_dll_u_control__2099_/Y VPWR VGND sg13cmos5l_dfrbpq_1
XFILLER_36_351 VPWR VGND sg13cmos5l_decap_8
XFILLER_28_307 VPWR VGND sg13cmos5l_fill_1
Xu_dll_u_control__2311_ u_dll_u_control__2311_/Q clkload0/A u_dll_u_control__2311_/D
+ u_dll_u_control__1971_/Y VPWR VGND sg13cmos5l_dfrbpq_1
Xu_dll_u_control__1124_ u_dll_u_control__1881_/C u_dll_u_control__1124_/A VPWR VGND
+ sg13cmos5l_inv_1
Xu_dll_u_control__2173_ u_dll_u_control__2173_/Q u_dll_u_control__2179_/CLK u_dll_u_control__2173_/D
+ u_dll_u_control__2030_/Y VPWR VGND sg13cmos5l_dfrbpq_1
Xclkload5 clkload5/Y clkload5/A VPWR VGND sg13cmos5l_inv_1
Xu_dll_u_control__1957_ u_dll_u_control__1957_/Y u_dll_u_control__2023_/A VPWR VGND
+ sg13cmos5l_inv_1
Xu_dll_u_ring_iss_core_delayinv1_u_inv u_dll_u_ring_iss_core_delayinv1_u_inv/Y u_dll_u_ring_iss_core_delayinv1_u_inv/A
+ VPWR VGND sg13cmos5l_inv_2
Xu_dll_u_ring_iss_core_merge_gate_u_nand u_dll_u_ring_iss_core_reset_gate_u_aoi/B1
+ u_dll_u_ring_iss_core_short_gate_u_nand/Y u_dll_u_ring_iss_core_long_gate_u_nand/Y
+ u_dll_u_ring_iss_core_reset_inv_u_inv/Y VPWR VGND sg13cmos5l_nand3_1
Xu_dll_u_control__1888_ u_dll_u_control__2297_/D u_dll_u_control__1896_/A u_dll_u_control__2291_/Q
+ VPWR VGND sg13cmos5l_and2_1
XFILLER_24_94 VPWR VGND sg13cmos5l_fill_2
XFILLER_40_60 VPWR VGND sg13cmos5l_decap_4
XFILLER_34_7 VPWR VGND sg13cmos5l_fill_1
XFILLER_6_266 VPWR VGND sg13cmos5l_decap_8
XFILLER_49_80 VPWR VGND sg13cmos5l_decap_8
XFILLER_37_148 VPWR VGND sg13cmos5l_decap_8
XFILLER_37_115 VPWR VGND sg13cmos5l_fill_1
XFILLER_37_104 VPWR VGND sg13cmos5l_decap_8
Xu_dll_u_control__1811_ u_dll_u_control__1816_/A u_dll_u_control__1812_/B u_dll_u_control__2163_/Q
+ VPWR VGND sg13cmos5l_nand2b_1
Xu_dll_u_control__1673_ u_dll_u_control__1673_/Y u_dll_u_control__1673_/A u_dll_u_control__1673_/B
+ u_dll_u_control__1673_/C VPWR VGND sg13cmos5l_nor3_1
Xu_dll_u_control__1742_ u_dll_u_control__1772_/B u_dll_u_control__1742_/A u_dll_u_control__1812_/B
+ VPWR VGND sg13cmos5l_nor2b_1
Xu_dll_u_div1_reset_buffer_u_buf u_dll_u_div1__105_/RESET_B u_dll__44_/Q VPWR VGND
+ sg13cmos5l_buf_4
Xu_dll_u_control__2225_ u_dll_u_control__2225_/Q u_dll_u_control__2231_/CLK u_dll_u_control__2225_/D
+ u_dll_u_control__2082_/Y VPWR VGND sg13cmos5l_dfrbpq_1
Xu_dll_u_control__1107_ u_dll_u_control__1884_/A u_dll_u_control__2138_/Q u_dll_u_control__2278_/Q
+ VPWR VGND sg13cmos5l_nand2_1
Xu_dll_u_control__2087_ u_dll_u_control__2087_/Y u_dll_u_control__2093_/A VPWR VGND
+ sg13cmos5l_inv_1
Xu_dll_u_control__2156_ u_dll_u_control__2156_/Q u_dll_u_control__2227_/CLK u_dll_u_control__2156_/D
+ u_dll_u_control__2013_/Y VPWR VGND sg13cmos5l_dfrbpq_1
XFILLER_47_402 VPWR VGND sg13cmos5l_fill_2
XFILLER_19_50 VPWR VGND sg13cmos5l_fill_1
XFILLER_19_137 VPWR VGND sg13cmos5l_fill_2
Xu_dll_u_div1_u_bypass_mux_u_merge u_dll_u_div1_u_run_gate_u_and/A u_dll_u_div1_u_bypass_mux_u_a0/Y
+ u_dll_u_div1_u_bypass_mux_u_a1/Y VPWR VGND sg13cmos5l_nand2_2
Xu_dll_u_div0_u_valid_gate_u_and u_dll_u_div0_u_bypass_mux_u_a0/A u_dll_u_div0_u_valid_gate_u_and/A
+ u_dll_u_div0__058_/Y VPWR VGND sg13cmos5l_and2_2
Xu_dll_u_ring_dstage\[7\].id_core_secondary_inv_u_inv u_dll_u_ring_dstage\[7\].id_core_short_decode_u_and/B
+ u_dll_u_ring_dstage\[7\].id_core_long_gate_u_nand/B VPWR VGND sg13cmos5l_inv_1
XFILLER_25_107 VPWR VGND sg13cmos5l_decap_4
XFILLER_33_195 VPWR VGND sg13cmos5l_fill_1
XFILLER_33_162 VPWR VGND sg13cmos5l_fill_1
XFILLER_33_140 VPWR VGND sg13cmos5l_decap_8
Xu_dll_u_control__2010_ u_dll_u_control__2010_/Y u_dll_u_control__2042_/A VPWR VGND
+ sg13cmos5l_inv_1
XFILLER_0_217 VPWR VGND sg13cmos5l_fill_1
Xu_dll_u_control__1656_ u_dll_u_control__2141_/D u_dll_u_control__1131_/A u_dll_u_control__1653_/A
+ u_dll_u_control__1653_/Y u_dll_u_control__1655_/Y VPWR VGND sg13cmos5l_a22oi_1
Xu_dll_u_control__1587_ u_dll_u_control__1588_/C u_dll_u_control__2135_/Q u_dll_u_control__2241_/Q
+ u_dll_u_control__1637_/A u_dll_u_control__1637_/B u_dll_u_control__1580_/X VPWR
+ VGND sg13cmos5l_a221oi_1
Xu_dll_u_control__1725_ u_dll_u_control__1725_/Y u_dll_u_control__1537_/Y u_dll_u_control__1725_/B
+ VPWR VGND sg13cmos5l_nand2b_1
Xu_dll_u_control__2139_ u_dll_u_control__2139_/Q u_dll_u_control__2145_/CLK u_dll_u_control__2139_/D
+ u_dll_u_control__1996_/Y VPWR VGND sg13cmos5l_dfrbpq_1
Xu_dll_u_control__2208_ u_dll_u_control__2208_/Q u_dll_u_control__2223_/CLK u_dll_u_control__2208_/D
+ u_dll_u_control__2065_/Y VPWR VGND sg13cmos5l_dfrbpq_1
XFILLER_47_210 VPWR VGND sg13cmos5l_fill_2
XFILLER_30_154 VPWR VGND sg13cmos5l_fill_1
Xu_dll_u_ring_dstage\[9\].id_core_delayinv1_u_inv u_dll_u_ring_dstage\[9\].id_core_delayinv1_u_inv/Y
+ u_dll_u_ring_dstage\[9\].id_core_delayinv1_u_inv/A VPWR VGND sg13cmos5l_inv_2
Xu_dll_u_ring_dstage\[3\].id_const0_u_lo u_dll_u_ring_dstage\[3\].id_const0_u_lo/L_LO
+ VPWR VGND sg13cmos5l_tielo
Xu_dll_u_control__1510_ u_dll_u_control__1567_/B u_dll_u_control__2223_/Q u_dll_u_control__1741_/B
+ VPWR VGND sg13cmos5l_or2_1
Xu_dll_u_control__1441_ u_dll_u_control__1442_/C u_dll_u_control__2174_/Q u_dll_u_control__1444_/B
+ VPWR VGND sg13cmos5l_nor2_1
Xu_dll_u_control__1372_ u_dll_u_control__1372_/Y u_dll_u_control__1351_/A u_dll_u_control__1371_/A
+ u_dll_u_control__1384_/A VPWR VGND sg13cmos5l_a21oi_1
Xu_dll_u_control__1708_ u_dll_u_control__1715_/A u_dll_u_control__2220_/Q u_dll_u_control__1741_/A
+ u_dll_u_control__1734_/A VPWR VGND sg13cmos5l_a21oi_1
Xu_dll_u_control__1639_ u_dll_u_control__1673_/B u_dll_u_control__2132_/Q u_dll_u_control__2238_/Q
+ VPWR VGND sg13cmos5l_xnor2_1
XFILLER_29_221 VPWR VGND sg13cmos5l_decap_4
XFILLER_29_210 VPWR VGND sg13cmos5l_fill_2
XFILLER_4_386 VPWR VGND sg13cmos5l_decap_8
Xu_dll_u_ring_dstage\[2\].id_core_trim_sync\[1\].applied_u_ff u_dll_u_ring_dstage\[2\].id_core_long_gate_u_nand/B
+ u_dll_u_ring_dstage\[2\].id_core_delayinv1_u_inv/Y u_dll_u_ring_dstage\[2\].id_core_trim_sync\[1\].meta_u_ff/Q
+ u_dll_u_ring_dstage\[2\].id_core_trim_reset_inv_u_inv/Y VPWR VGND sg13cmos5l_dfrbpq_1
Xu_dll_u_control__1990_ u_dll_u_control__1990_/Y u_dll_u_control__2095_/A VPWR VGND
+ sg13cmos5l_inv_1
Xu_dll_u_control__1424_ u_dll_u_control__1901_/C u_dll_u_control__2167_/Q u_dll_u_control__1424_/B
+ u_dll_u_control__1424_/C VPWR VGND sg13cmos5l_nor3_1
Xu_dll_u_control__1355_ u_dll_u_control__1355_/Y u_dll_u_control__1371_/A u_dll_u_control__1355_/B
+ VPWR VGND sg13cmos5l_nor2_1
Xu_dll_u_control__1286_ u_dll_u_control__2263_/D u_dll_u_control__1256_/B u_dll_u_control__1281_/Y
+ u_dll_u_control__1280_/A VPWR VGND sg13cmos5l_a21oi_1
Xu_dll_u_ring_dstage\[7\].id_core_short_decode_u_and u_dll_u_ring_dstage\[7\].id_core_short_gate_u_nand/B
+ u_dll_u_ring_dstage\[7\].id_core_delaymux1_u_a1/B u_dll_u_ring_dstage\[7\].id_core_short_decode_u_and/B
+ VPWR VGND sg13cmos5l_and2_2
XFILLER_1_367 VPWR VGND sg13cmos5l_decap_8
XFILLER_32_227 VPWR VGND sg13cmos5l_decap_4
XFILLER_27_83 VPWR VGND sg13cmos5l_fill_2
XFILLER_43_71 VPWR VGND sg13cmos5l_decap_4
XFILLER_25_290 VPWR VGND sg13cmos5l_fill_1
Xu_dll_u_div1__098_ u_dll_u_div1__107_/D u_dll_u_div1__112_/Q VPWR VGND sg13cmos5l_buf_1
Xu_dll_u_control__1140_ u_dll_u_control__1140_/X u_dll_u_control__1147_/B u_dll_u_control__1147_/C
+ VPWR VGND sg13cmos5l_and2_1
Xu_dll_u_control__1071_ u_dll_u_control__1071_/Y u_dll_u_control__2266_/Q VPWR VGND
+ sg13cmos5l_inv_1
Xu_dll_u_control__1973_ u_dll_u_control__1973_/Y u_dll_u_control__2127_/A VPWR VGND
+ sg13cmos5l_inv_1
Xu_dll_u_ring_dstage\[3\].id_core_delaymux1_u_a0 u_dll_u_ring_dstage\[3\].id_core_delaymux1_u_a0/Y
+ u_dll_u_ring_dstage\[3\].id_core_delaymux1_u_a0/A u_dll_u_ring_dstage\[3\].id_core_delaymux1_u_a0/B
+ VPWR VGND sg13cmos5l_nand2_2
XFILLER_39_360 VPWR VGND sg13cmos5l_fill_2
Xu_dll_u_control__1338_ u_dll_u_control__1338_/Y u_dll_u_control__2204_/Q u_dll_u_control__1338_/B
+ VPWR VGND sg13cmos5l_nand2b_1
XFILLER_14_216 VPWR VGND sg13cmos5l_fill_1
Xu_dll_u_control__1407_ u_dll_u_control__2183_/D u_dll_u_control__1377_/B u_dll_u_control__1386_/C
+ u_dll_u_control__1406_/Y VPWR VGND sg13cmos5l_o21ai_1
Xu_dll_u_control__1269_ u_dll_u_control__2260_/D u_dll_u_control__1859_/A u_dll_u_control__1268_/Y
+ u_dll_u_control__1860_/A VPWR VGND sg13cmos5l_a21oi_1
XFILLER_22_282 VPWR VGND sg13cmos5l_decap_8
XFILLER_49_102 VPWR VGND sg13cmos5l_fill_1
XFILLER_45_330 VPWR VGND sg13cmos5l_fill_1
Xu_dll_u_ring_dstage\[8\].id_const0_u_lo u_dll_u_ring_dstage\[8\].id_const0_u_lo/L_LO
+ VPWR VGND sg13cmos5l_tielo
XFILLER_45_363 VPWR VGND sg13cmos5l_decap_8
XFILLER_9_231 VPWR VGND sg13cmos5l_decap_8
XFILLER_9_297 VPWR VGND sg13cmos5l_decap_8
XFILLER_13_271 VPWR VGND sg13cmos5l_fill_1
Xu_dll_u_control__2241_ u_dll_u_control__2241_/Q u_dll_u_control__2274_/CLK u_dll_u_control__2241_/D
+ u_dll_u_control__2098_/Y VPWR VGND sg13cmos5l_dfrbpq_1
XFILLER_36_363 VPWR VGND sg13cmos5l_decap_8
Xu_dll_u_control__2172_ u_dll_u_control__2172_/Q u_dll_u_control__2172_/CLK u_dll_u_control__2172_/D
+ u_dll_u_control__2029_/Y VPWR VGND sg13cmos5l_dfrbpq_1
Xu_dll_u_control__2310_ u_dll_u_control__2310_/Q u_dll_u_control__2312_/CLK u_dll_u_control__2310_/D
+ u_dll_u_control__1970_/Y VPWR VGND sg13cmos5l_dfrbpq_1
Xu_dll_u_control__1123_ u_dll_u_control__1124_/A u_dll_u_control__2138_/Q u_dll_u_control__2278_/Q
+ VPWR VGND sg13cmos5l_xnor2_1
Xclkload6 clkload6/Y clkload6/A VPWR VGND sg13cmos5l_inv_1
XFILLER_11_219 VPWR VGND sg13cmos5l_decap_8
Xu_dll_u_control__1956_ u_dll_u_control__1956_/Y u_dll_u_control__2049_/A VPWR VGND
+ sg13cmos5l_inv_1
Xu_dll_u_control__1887_ u_dll_u_control__2295_/D u_dll_u_control__1896_/A u_dll_u_control__2209_/Q
+ VPWR VGND sg13cmos5l_and2_1
XFILLER_40_72 VPWR VGND sg13cmos5l_decap_4
XFILLER_6_245 VPWR VGND sg13cmos5l_decap_8
XFILLER_6_212 VPWR VGND sg13cmos5l_fill_2
XFILLER_24_84 VPWR VGND sg13cmos5l_fill_2
Xu_dll_u_div0__099_ u_dll_u_div0__100_/D u_dll_u_div0__056_/A u_dll_u_div0__099_/D
+ u_dll_u_div0__105_/RESET_B VPWR VGND sg13cmos5l_dfrbpq_1
XFILLER_1_55 VPWR VGND sg13cmos5l_fill_2
XFILLER_33_355 VPWR VGND sg13cmos5l_fill_1
Xu_dll_u_control__1741_ u_dll_u_control__2208_/D u_dll_u_control__1741_/A u_dll_u_control__1741_/B
+ u_dll_u_control__1741_/C VPWR VGND sg13cmos5l_nor3_1
Xu_dll_u_control__1810_ u_dll_u_control__1813_/A u_dll_u_control__2162_/Q u_dll_u_control__1300_/A
+ u_dll_u_control__1809_/C VPWR VGND sg13cmos5l_a21oi_1
Xu_dll_u_control__1672_ u_dll_u_control__2133_/D u_dll_u_control__2133_/Q u_dll_u_control__1673_/A
+ u_dll_u_control__1671_/Y VPWR VGND sg13cmos5l_a21o_1
XFILLER_28_105 VPWR VGND sg13cmos5l_fill_2
XFILLER_29_29 VPWR VGND sg13cmos5l_fill_2
XFILLER_43_119 VPWR VGND sg13cmos5l_decap_4
Xu_dll_u_control__2224_ u_dll_u_control__2224_/Q u_dll_u_control__2231_/CLK u_dll_u_control__2224_/D
+ u_dll_u_control__2081_/Y VPWR VGND sg13cmos5l_dfrbpq_1
Xu_dll_u_control__2155_ u_dll_u_control__2155_/Q u_dll_u_control__2227_/CLK u_dll_u_control__2155_/D
+ u_dll_u_control__2012_/Y VPWR VGND sg13cmos5l_dfrbpq_1
Xu_dll_u_control__1106_ u_dll_u_control__1106_/Y u_dll_u_control__2139_/Q u_dll_u_control__2279_/Q
+ VPWR VGND sg13cmos5l_nand2_1
Xu_dll_u_control__2086_ u_dll_u_control__2086_/Y u_dll_u_control__2093_/A VPWR VGND
+ sg13cmos5l_inv_1
Xu_dll_u_control__1939_ u_dll_u_control__1939_/Y u_dll_u_control__1999_/A VPWR VGND
+ sg13cmos5l_inv_1
XFILLER_30_303 VPWR VGND sg13cmos5l_decap_4
XFILLER_38_403 VPWR VGND sg13cmos5l_fill_1
XFILLER_25_4 VPWR VGND sg13cmos5l_fill_2
XFILLER_21_358 VPWR VGND sg13cmos5l_decap_8
Xu_dll_u_control__1724_ u_dll_u_control__1725_/B u_dll_u_control__2322_/Q u_dll_u_control__1724_/B
+ VPWR VGND sg13cmos5l_nand2_1
Xu_dll_u_control__1655_ u_dll_u_control__1655_/Y u_dll_u_control__1643_/B u_dll_u_control__1657_/B
+ VPWR VGND sg13cmos5l_nand2b_1
Xu_dll_u_control__1586_ u_dll_u_control__1636_/A u_dll_u_control__1637_/A u_dll_u_control__1637_/B
+ u_dll_u_control__1580_/X VPWR VGND sg13cmos5l_a21oi_1
XFILLER_29_403 VPWR VGND sg13cmos5l_fill_1
Xu_dll_u_control__2138_ u_dll_u_control__2138_/Q u_dll_u_control__2277_/CLK u_dll_u_control__2138_/D
+ u_dll_u_control__1995_/Y VPWR VGND sg13cmos5l_dfrbpq_1
Xu_dll_u_control__2207_ u_dll_u_control__2207_/Q u_dll_u_control__2207_/CLK u_dll_u_control__2207_/D
+ u_dll_u_control__2064_/Y VPWR VGND sg13cmos5l_dfrbpq_1
Xu_dll_u_control__2069_ u_dll_u_control__2069_/Y u_dll_u_control__2125_/A VPWR VGND
+ sg13cmos5l_inv_1
Xu_dll_u_control__1440_ u_dll_u_control__2175_/D u_dll_u_control__2175_/Q u_dll_u_control__1442_/B
+ u_dll_u_control__1439_/Y VPWR VGND sg13cmos5l_a21oi_1
Xu_dll_u_control__1371_ u_dll_u_control__1373_/A u_dll_u_control__1371_/A u_dll_u_control__1371_/B
+ VPWR VGND sg13cmos5l_nor2_1
Xu_dll_u_control__1707_ u_dll_u_control__1734_/A u_dll_u_control__1814_/A u_dll_u_control__2223_/Q
+ u_dll_u_control__1707_/C VPWR VGND sg13cmos5l_nand3_1
Xu_dll_u_control__1638_ u_dll_u_control__1671_/B u_dll_u_control__1638_/A u_dll_u_control__1638_/B
+ VPWR VGND sg13cmos5l_xnor2_1
Xu_dll_u_control__1569_ u_dll_u_control__1616_/B u_dll_u_control__1618_/A u_dll_u_control__1618_/B
+ VPWR VGND sg13cmos5l_nor2_1
XFILLER_16_30 VPWR VGND sg13cmos5l_decap_8
XFILLER_4_365 VPWR VGND sg13cmos5l_decap_8
Xu_dll_u_control__1423_ u_dll_u_control__1424_/C u_dll_u_control__2172_/Q u_dll_u_control__2171_/Q
+ VPWR VGND sg13cmos5l_nand2_1
Xu_dll_u_control__1354_ u_dll_u_control__1355_/B u_dll_u_control__2201_/Q u_dll_u_control__1354_/B
+ VPWR VGND sg13cmos5l_xnor2_1
XFILLER_41_217 VPWR VGND sg13cmos5l_fill_2
Xu_dll__29_ u_dll__29_/X u_dll__29_/A u_dll__29_/B VPWR VGND sg13cmos5l_and2_1
Xu_dll_u_control__1285_ u_dll_u_control__2264_/D u_dll_u_control__1285_/A u_dll_u_control__1285_/B
+ VPWR VGND sg13cmos5l_nor2_1
XFILLER_27_73 VPWR VGND sg13cmos5l_decap_8
XFILLER_43_83 VPWR VGND sg13cmos5l_fill_1
XFILLER_9_402 VPWR VGND sg13cmos5l_fill_2
XFILLER_4_77 VPWR VGND sg13cmos5l_fill_1
Xu_dll_u_div1__097_ u_dll_u_div1__099_/D u_dll_u_div1__097_/A u_dll_u_div1__097_/B
+ u_dll_u_div1__097_/C VPWR VGND sg13cmos5l_nor3_1
Xu_dll_u_control__1070_ u_dll_u_control__1070_/Y u_dll_u_control__2267_/Q VPWR VGND
+ sg13cmos5l_inv_1
Xu_dll_u_control__1972_ u_dll_u_control__1972_/Y u_dll_u_control__2127_/A VPWR VGND
+ sg13cmos5l_inv_1
Xu_dll_u_ring_dstage\[3\].id_core_delaymux1_u_a1 u_dll_u_ring_dstage\[3\].id_core_delaymux1_u_a1/Y
+ u_dll_u_ring_dstage\[3\].id_core_delaymux1_u_a1/A u_dll_u_ring_dstage\[3\].id_core_delaymux1_u_a1/B
+ VPWR VGND sg13cmos5l_nand2_2
Xu_dll_u_control__1268_ u_dll_u_control__1268_/Y u_dll_u_control__1829_/A u_dll_u_control__1834_/B
+ u_dll_u_control__1827_/B VPWR VGND sg13cmos5l_nand3_1
Xu_dll_u_control__1337_ u_dll_u_control__2205_/D u_dll_u_control__1337_/A u_dll_u_control__1336_/Y
+ VPWR VGND sg13cmos5l_nor2b_1
Xu_dll_u_control__1406_ u_dll_u_control__1406_/Y u_dll_u_control__2183_/Q u_dll_u_control__1410_/B
+ VPWR VGND sg13cmos5l_nand2_1
Xu_dll_u_control__1199_ u_dll_u_control__1199_/Y u_dll_u_control__1192_/Y u_dll_u_control__1196_/Y
+ u_dll_u_control__1198_/Y VPWR VGND sg13cmos5l_o21ai_1
Xu_dll_u_div0_u_output_inv1_u_inv u_dll_u_div0_u_clkbuf_out_u_buf/A u_dll_u_div0_u_output_inv1_u_inv/A
+ VPWR VGND sg13cmos5l_inv_2
Xu_dll_u_ring_dstage\[1\].id_core_delayint0_u_inv u_dll_u_ring_dstage\[1\].id_core_delaymux1_u_a0/A
+ u_dll_u_ring_dstage\[1\].id_core_delayinv1_u_inv/Y VPWR VGND sg13cmos5l_inv_1
XFILLER_22_261 VPWR VGND sg13cmos5l_decap_8
XFILLER_49_169 VPWR VGND sg13cmos5l_decap_8
Xu_dll_u_ring_dstage\[10\].id_core_trim_sync\[1\].applied_u_ff u_dll_u_ring_dstage\[10\].id_core_long_gate_u_nand/B
+ u_dll_u_ring_dstage\[10\].id_core_delayinv1_u_inv/Y u_dll_u_ring_dstage\[10\].id_core_trim_sync\[1\].meta_u_ff/Q
+ u_dll_u_ring_dstage\[10\].id_core_trim_reset_inv_u_inv/Y VPWR VGND sg13cmos5l_dfrbpq_1
Xu_dll_u_ring_dstage\[10\].id_const0_u_hi u_dll_u_ring_dstage\[10\].id_const0_u_hi/L_HI
+ VPWR VGND sg13cmos5l_tiehi
XFILLER_9_254 VPWR VGND sg13cmos5l_decap_8
Xu_dll_u_control__1122_ u_dll_u_control__1881_/B u_dll_u_control__1879_/A u_dll_u_control__1879_/B
+ u_dll_u_control__1879_/C VPWR VGND sg13cmos5l_a21oi_1
Xu_dll_u_control__2240_ u_dll_u_control__2240_/Q u_dll_u_control__2317_/CLK u_dll_u_control__2240_/D
+ u_dll_u_control__2097_/Y VPWR VGND sg13cmos5l_dfrbpq_1
Xu_dll_u_control__2171_ u_dll_u_control__2171_/Q u_dll_u_control__2179_/CLK u_dll_u_control__2171_/D
+ u_dll_u_control__2028_/Y VPWR VGND sg13cmos5l_dfrbpq_1
Xclkload7 clkload7/Y clkload7/A VPWR VGND sg13cmos5l_inv_1
Xu_dll_u_control__1886_ u_dll_u_control__2296_/D u_dll_u_control__1896_/A u_dll_u_control__2295_/Q
+ VPWR VGND sg13cmos5l_and2_1
Xu_dll_u_control__1955_ u_dll_u_control__1955_/Y u_dll_u_control__2049_/A VPWR VGND
+ sg13cmos5l_inv_1
XFILLER_46_139 VPWR VGND sg13cmos5l_fill_2
XFILLER_46_128 VPWR VGND sg13cmos5l_decap_8
XFILLER_42_389 VPWR VGND sg13cmos5l_decap_8
Xu_dll_u_div0__098_ u_dll_u_div0__107_/D u_dll_u_div0__112_/Q VPWR VGND sg13cmos5l_buf_1
XFILLER_18_397 VPWR VGND sg13cmos5l_decap_8
Xu_dll_u_control__1671_ u_dll_u_control__1671_/Y u_dll_u_control__1673_/A u_dll_u_control__1671_/B
+ u_dll_u_control__1673_/C VPWR VGND sg13cmos5l_nor3_1
XFILLER_46_0 VPWR VGND sg13cmos5l_decap_8
Xu_dll_u_control__1740_ u_dll_u_control__1741_/C u_dll_u_control__2221_/Q u_dll_u_control__1610_/Y
+ u_dll_u_control__1739_/Y VPWR VGND sg13cmos5l_a21oi_1
XFILLER_28_128 VPWR VGND sg13cmos5l_fill_1
Xu_dll_u_control__1105_ u_dll_u_control__1142_/B u_dll_u_control__2139_/Q u_dll_u_control__2279_/Q
+ VPWR VGND sg13cmos5l_and2_1
XFILLER_36_172 VPWR VGND sg13cmos5l_fill_2
Xu_dll_u_control__2223_ u_dll_u_control__2223_/Q u_dll_u_control__2223_/CLK u_dll_u_control__2223_/D
+ u_dll_u_control__2080_/Y VPWR VGND sg13cmos5l_dfrbpq_1
Xu_dll_u_ring_dstage\[6\].id_core_trim_sync\[0\].applied_u_ff u_dll_u_ring_dstage\[6\].id_core_delaymux1_u_a1/B
+ u_dll_u_ring_dstage\[6\].id_core_delayinv1_u_inv/Y u_dll_u_ring_dstage\[6\].id_core_trim_sync\[0\].meta_u_ff/Q
+ u_dll_u_ring_dstage\[6\].id_core_trim_reset_inv_u_inv/Y VPWR VGND sg13cmos5l_dfrbpq_1
Xu_dll_u_control__2154_ u_dll_u_control__2154_/Q u_dll_u_control__2161_/CLK u_dll_u_control__2154_/D
+ u_dll_u_control__2011_/Y VPWR VGND sg13cmos5l_dfrbpq_1
Xu_dll_u_control__2085_ u_dll_u_control__2085_/Y u_dll_u_control__2085_/A VPWR VGND
+ sg13cmos5l_inv_1
XFILLER_24_301 VPWR VGND sg13cmos5l_fill_1
Xu_dll__37__122 u_dll__37_/D VPWR VGND sg13cmos5l_tiehi
Xu_dll_u_control__1938_ u_dll_u_control__1938_/Y u_dll_u_control__1999_/A VPWR VGND
+ sg13cmos5l_inv_1
Xu_dll_u_control__1869_ u_dll_u_control__2272_/D u_dll_u_control__1869_/A u_dll_u_control__1114_/Y
+ VPWR VGND sg13cmos5l_nor2b_1
XFILLER_35_51 VPWR VGND sg13cmos5l_fill_1
XFILLER_27_194 VPWR VGND sg13cmos5l_fill_2
XFILLER_27_161 VPWR VGND sg13cmos5l_fill_2
XFILLER_15_323 VPWR VGND sg13cmos5l_fill_1
XFILLER_19_139 VPWR VGND sg13cmos5l_fill_1
XFILLER_35_95 VPWR VGND sg13cmos5l_fill_2
XFILLER_18_4 VPWR VGND sg13cmos5l_fill_2
Xu_dll_u_control__1654_ u_dll_u_control__2142_/D u_dll_u_control__1552_/B u_dll_u_control__1653_/A
+ u_dll_u_control__1651_/Y u_dll_u_control__1653_/Y VPWR VGND sg13cmos5l_a22oi_1
Xu_dll_u_control__1723_ u_dll_u_control__1723_/X u_dll_u_control__1723_/A u_dll_u_control__1723_/B
+ VPWR VGND sg13cmos5l_or2_1
Xclkbuf_5_2__f_u_dll\_controller_ref_clk u_dll_u_control__2161_/CLK clkbuf_4_1_0_u_dll\_controller_ref_clk/X
+ VPWR VGND sg13cmos5l_buf_8
Xu_dll_u_control__1585_ u_dll_u_control__1637_/B u_dll_u_control__2134_/Q u_dll_u_control__2240_/Q
+ VPWR VGND sg13cmos5l_xor2_1
Xu_dll_u_control__2137_ u_dll_u_control__2137_/Q u_dll_u_control__2277_/CLK u_dll_u_control__2137_/D
+ u_dll_u_control__1994_/Y VPWR VGND sg13cmos5l_dfrbpq_1
Xu_dll_u_control__2068_ u_dll_u_control__2068_/Y u_dll_u_control__2125_/A VPWR VGND
+ sg13cmos5l_inv_1
XFILLER_8_308 VPWR VGND sg13cmos5l_fill_1
Xu_dll_u_control__2206_ u_dll_u_control__2206_/Q u_dll_u_control__2206_/CLK u_dll_u_control__2206_/D
+ u_dll_u_control__2063_/Y VPWR VGND sg13cmos5l_dfrbpq_1
Xclkbuf_4_13__f_u_dll\_controller_ring_clk u_dll_u_control__2298_/CLK clkbuf_3_6_0_u_dll\_controller_ring_clk/X
+ VPWR VGND sg13cmos5l_buf_8
XFILLER_21_64 VPWR VGND sg13cmos5l_decap_8
XFILLER_47_256 VPWR VGND sg13cmos5l_decap_4
XFILLER_7_330 VPWR VGND sg13cmos5l_fill_2
Xu_dll_u_control__1370_ u_dll_u_control__1371_/B u_dll_u_control__2197_/Q u_dll_u_control__1370_/B
+ VPWR VGND sg13cmos5l_xnor2_1
Xu_dll_u_control__1637_ u_dll_u_control__1669_/B u_dll_u_control__1637_/A u_dll_u_control__1637_/B
+ VPWR VGND sg13cmos5l_xnor2_1
Xu_dll_u_control__1706_ u_dll_u_control__2216_/D u_dll_u_control__1706_/A u_dll_u_control__1706_/B
+ VPWR VGND sg13cmos5l_nor2_1
XFILLER_29_212 VPWR VGND sg13cmos5l_fill_1
Xu_dll_u_control__1568_ u_dll_u_control__2151_/D u_dll_u_control__1565_/A u_dll_u_control__1566_/Y
+ u_dll_u_control__1567_/Y VPWR VGND sg13cmos5l_o21ai_1
Xu_dll_u_ring_dstage\[11\].id_core_short_decode_u_and u_dll_u_ring_dstage\[11\].id_core_short_gate_u_nand/B
+ u_dll_u_ring_dstage\[11\].id_core_delaymux1_u_a1/B u_dll_u_ring_dstage\[11\].id_core_short_decode_u_and/B
+ VPWR VGND sg13cmos5l_and2_2
Xu_dll_u_control__1499_ u_dll_u_control__2156_/D u_dll_u_control__1508_/A u_dll_u_control__1499_/B
+ u_dll_u_control__1499_/C VPWR VGND sg13cmos5l_nor3_1
XFILLER_12_112 VPWR VGND sg13cmos5l_fill_2
XFILLER_12_178 VPWR VGND sg13cmos5l_fill_2
XFILLER_4_344 VPWR VGND sg13cmos5l_decap_8
Xu_dll_u_control__1284_ u_dll_u_control__1285_/B u_dll_u_control__1846_/A u_dll_u_control__1284_/B
+ u_dll_u_control__1864_/B VPWR VGND sg13cmos5l_nor3_1
Xu_dll_u_control__1422_ u_dll_u_control__1424_/B u_dll_u_control__2170_/Q u_dll_u_control__2169_/Q
+ u_dll_u_control__2168_/Q VPWR VGND sg13cmos5l_nand3_1
Xu_dll_u_control__1353_ u_dll_u_control__1354_/B u_dll_u_control__1353_/A u_dll_u_control__1370_/B
+ VPWR VGND sg13cmos5l_or2_1
Xu_dll_u_div1_fanout60 u_dll_u_div1_fanout60/X u_dll_fanout61/X VPWR VGND sg13cmos5l_buf_1
Xu_dll_u_ring_dstage\[3\].id_core_reset_gate_u_aoi u_dll_u_ring_dstage\[3\].id_core_reset_gate_u_aoi/Y
+ u_dll_u_ring_dstage\[2\].id_core_reset_gate_u_aoi/Y u_dll_u_ring_dstage\[3\].id_core_reset_gate_u_aoi/A2
+ u_dll_u_ring_dstage\[3\].id_core_reset_gate_u_aoi/B1 VPWR VGND sg13cmos5l_a21oi_2
Xu_dll__28_ u_dll__28_/X u_dll__29_/A u_dll__29_/B VPWR VGND sg13cmos5l_and2_1
Xclkbuf_5_13__f_u_dll\_controller_ref_clk clkload3/A clkbuf_4_6_0_u_dll\_controller_ref_clk/X
+ VPWR VGND sg13cmos5l_buf_8
Xu_pad1_u_buf analog_1 u_pad1_u_buf/A VPWR VGND sg13cmos5l_buf_8
XFILLER_27_85 VPWR VGND sg13cmos5l_fill_1
XFILLER_48_384 VPWR VGND sg13cmos5l_decap_8
Xu_dll_u_div1__096_ u_dll_u_div1__097_/C u_dll_u_div1__080_/C u_dll_u_div1__095_/Y
+ u_dll_u_div1__100_/D VPWR VGND sg13cmos5l_a21oi_1
Xu_dll_u_ring_dstage\[2\].id_core_delayinv1_u_inv u_dll_u_ring_dstage\[2\].id_core_delayinv1_u_inv/Y
+ u_dll_u_ring_dstage\[2\].id_core_delayinv1_u_inv/A VPWR VGND sg13cmos5l_inv_2
Xu_dll_u_control__1971_ u_dll_u_control__1971_/Y u_dll_u_control__2127_/A VPWR VGND
+ sg13cmos5l_inv_1
Xu_dll_u_control__1405_ u_dll_u_control__2184_/D u_dll_u_control__1373_/A u_dll_u_control__1386_/C
+ u_dll_u_control__1404_/Y VPWR VGND sg13cmos5l_o21ai_1
Xu_dll_u_control__1267_ u_dll_u_control__1267_/Y u_dll_u_control__1851_/A u_dll_u_control__1851_/C
+ u_dll_u_control__1846_/B u_dll_u_control__1844_/B VPWR VGND sg13cmos5l_nor4_1
Xu_dll_u_control__1336_ u_dll_u_control__1336_/Y u_dll_u_control__1923_/B u_dll_u_control__1924_/A1
+ u_dll_u_control__1345_/A VPWR VGND sg13cmos5l_a21oi_1
XFILLER_14_207 VPWR VGND sg13cmos5l_fill_2
XFILLER_22_240 VPWR VGND sg13cmos5l_decap_8
Xu_dll_u_control__1198_ u_dll_u_control__1198_/Y u_dll_u_control__1163_/A u_dll_u_control__1215_/A
+ u_dll_u_control__1230_/A u_dll_u_control__1201_/A VPWR VGND sg13cmos5l_a22oi_1
XFILLER_38_51 VPWR VGND sg13cmos5l_fill_1
XFILLER_45_398 VPWR VGND sg13cmos5l_decap_4
Xclkbuf_4_9__f_u_dll\_controller_ring_clk u_dll_u_control__2301_/CLK clkbuf_3_4_0_u_dll\_controller_ring_clk/X
+ VPWR VGND sg13cmos5l_buf_8
Xu_dll_u_control__1121_ u_dll_u_control__1879_/C u_dll_u_control__2137_/Q u_dll_u_control__2277_/Q
+ VPWR VGND sg13cmos5l_xnor2_1
Xu_dll_u_div1__079_ u_dll_u_div1__080_/C u_dll_u_div1__101_/Q u_dll_u_div1__102_/Q
+ VPWR VGND sg13cmos5l_nor2_1
XFILLER_36_398 VPWR VGND sg13cmos5l_decap_4
XFILLER_36_321 VPWR VGND sg13cmos5l_decap_8
Xu_dll_u_control__2170_ u_dll_u_control__2170_/Q u_dll_u_control__2179_/CLK u_dll_u_control__2170_/D
+ u_dll_u_control__2027_/Y VPWR VGND sg13cmos5l_dfrbpq_1
Xclkload8 clkload8/Y clkload8/A VPWR VGND sg13cmos5l_inv_1
Xu_dll_u_control__1885_ u_dll_u_control__2279_/D u_dll_u_control__1885_/A u_dll_u_control__1885_/B
+ u_dll_u_control__1885_/C VPWR VGND sg13cmos5l_and3_1
Xu_dll_u_control__1954_ u_dll_u_control__1954_/Y u_dll_u_control__2035_/A VPWR VGND
+ sg13cmos5l_inv_1
XFILLER_42_379 VPWR VGND sg13cmos5l_fill_2
Xu_dll_u_control__2299_ u_dll_u_control__2299_/Q u_dll_u_control__2299_/CLK u_dll_u_control__2299_/D
+ u_dll_u_control__1959_/Y VPWR VGND sg13cmos5l_dfrbpq_1
XFILLER_10_232 VPWR VGND sg13cmos5l_fill_2
Xu_dll_u_control__1319_ u_dll_u_control__1345_/A u_dll_u_control__1921_/B u_dll_u_control__1319_/B
+ VPWR VGND sg13cmos5l_nand2_1
XFILLER_24_42 VPWR VGND sg13cmos5l_fill_2
Xclkbuf_0_u_dll\_controller_ref_clk clkbuf_0_u_dll\_controller_ref_clk/X u_dll_u_ref_buffer_u_buf/X
+ VPWR VGND sg13cmos5l_buf_8
Xu_dll_u_div0__097_ u_dll_u_div0__099_/D u_dll_u_div0__097_/A u_dll_u_div0__097_/B
+ u_dll_u_div0__097_/C VPWR VGND sg13cmos5l_nor3_1
XFILLER_6_214 VPWR VGND sg13cmos5l_fill_1
XFILLER_49_94 VPWR VGND sg13cmos5l_fill_2
XFILLER_33_335 VPWR VGND sg13cmos5l_fill_1
XFILLER_33_324 VPWR VGND sg13cmos5l_decap_8
Xu_dll_u_control__1670_ u_dll_u_control__2134_/D u_dll_u_control__2134_/Q u_dll_u_control__1673_/A
+ u_dll_u_control__1669_/Y VPWR VGND sg13cmos5l_a21o_1
Xu_dll_u_ring_dstage\[1\].id_core_trim_sync\[0\].applied_u_ff u_dll_u_ring_dstage\[1\].id_core_delaymux1_u_a1/B
+ u_dll_u_ring_dstage\[1\].id_core_delayinv1_u_inv/Y u_dll_u_ring_dstage\[1\].id_core_trim_sync\[0\].meta_u_ff/Q
+ u_dll_u_ring_dstage\[1\].id_core_trim_reset_inv_u_inv/Y VPWR VGND sg13cmos5l_dfrbpq_1
XFILLER_36_151 VPWR VGND sg13cmos5l_fill_2
Xu_dll_u_div0_u_output_inv0_u_inv u_dll_u_div0_u_output_inv1_u_inv/A u_dll_u_div0_u_run_gate_u_and/X
+ VPWR VGND sg13cmos5l_inv_2
XFILLER_28_118 VPWR VGND sg13cmos5l_fill_2
Xu_dll_u_control__2222_ u_dll_u_control__2222_/Q u_dll_u_control__2268_/CLK u_dll_u_control__2222_/D
+ u_dll_u_control__2079_/Y VPWR VGND sg13cmos5l_dfrbpq_1
Xclkbuf_2_0_0_u_dll\_controller_ref_clk clkbuf_4_3_0_u_dll\_controller_ref_clk/A clkbuf_2_1_0_u_dll\_controller_ref_clk/A
+ VPWR VGND sg13cmos5l_buf_8
Xu_dll_u_control__1104_ u_dll_u_control__1899_/B u_dll_u_control__2305_/Q VPWR VGND
+ sg13cmos5l_inv_1
Xu_dll_u_control__2153_ u_dll_u_control__2153_/Q u_dll_u_control__2161_/CLK u_dll_u_control__2153_/D
+ u_dll_u_control__2010_/Y VPWR VGND sg13cmos5l_dfrbpq_1
Xu_dll_u_control__2084_ u_dll_u_control__2084_/Y u_dll_u_control__2085_/A VPWR VGND
+ sg13cmos5l_inv_1
Xu_dll_u_control__1937_ u_dll_u_control__1937_/Y u_dll_u_control__1999_/A VPWR VGND
+ sg13cmos5l_inv_1
XFILLER_10_55 VPWR VGND sg13cmos5l_fill_1
Xu_dll_u_ring_dstage\[2\].id_core_delaymux1_u_merge u_dll_u_ring_dstage\[2\].id_core_long_gate_u_nand/A
+ u_dll_u_ring_dstage\[2\].id_core_delaymux1_u_a0/Y u_dll_u_ring_dstage\[2\].id_core_delaymux1_u_a1/Y
+ VPWR VGND sg13cmos5l_nand2_2
Xu_dll_u_control__1868_ u_dll_u_control__1869_/A u_dll_u_control__2132_/Q u_dll_u_control__2272_/Q
+ u_dll_u_control__1878_/B VPWR VGND sg13cmos5l_o21ai_1
Xu_dll_u_control__1799_ u_dll_u_control__1800_/B u_dll_u_control__2160_/Q u_dll_u_control__2320_/Q
+ VPWR VGND sg13cmos5l_xnor2_1
XFILLER_27_140 VPWR VGND sg13cmos5l_fill_1
XFILLER_30_349 VPWR VGND sg13cmos5l_decap_4
XFILLER_30_338 VPWR VGND sg13cmos5l_fill_2
XFILLER_30_327 VPWR VGND sg13cmos5l_decap_8
XFILLER_30_316 VPWR VGND sg13cmos5l_decap_4
Xu_dll_u_ring_dstage\[5\].id_core_delaymux1_u_sel u_dll_u_ring_dstage\[5\].id_core_delaymux1_u_a0/B
+ u_dll_u_ring_dstage\[5\].id_core_delaymux1_u_a1/B VPWR VGND sg13cmos5l_inv_1
XFILLER_21_349 VPWR VGND sg13cmos5l_decap_4
Xu_dll_u_control__1584_ u_dll_u_control__1637_/A u_dll_u_control__1638_/A u_dll_u_control__1638_/B
+ u_dll_u_control__1581_/Y VPWR VGND sg13cmos5l_o21ai_1
Xu_dll_u_control__1653_ u_dll_u_control__1653_/Y u_dll_u_control__1653_/A u_dll_u_control__1653_/B
+ VPWR VGND sg13cmos5l_nor2_1
Xu_dll_u_control__1722_ u_dll_u_control__1722_/Y u_dll_u_control__1469_/A u_dll_u_control__1297_/B
+ u_dll_u_control__2209_/Q VPWR VGND sg13cmos5l_o21ai_1
Xu_dll_u_control__2205_ u_dll_u_control__2205_/Q u_dll_u_control__2315_/CLK u_dll_u_control__2205_/D
+ u_dll_u_control__2062_/Y VPWR VGND sg13cmos5l_dfrbpq_1
Xu_dll_u_control__2136_ u_dll_u_control__2136_/Q u_dll_u_control__2275_/CLK u_dll_u_control__2136_/D
+ u_dll_u_control__1993_/Y VPWR VGND sg13cmos5l_dfrbpq_1
Xu_dll_u_control__2067_ u_dll_u_control__2067_/Y u_dll_u_control__2102_/A VPWR VGND
+ sg13cmos5l_inv_1
XFILLER_47_246 VPWR VGND sg13cmos5l_fill_2
XFILLER_46_84 VPWR VGND sg13cmos5l_fill_2
XFILLER_11_382 VPWR VGND sg13cmos5l_fill_2
Xu_dll__44_ u_dll__44_/Q u_dll__31_/Y u_dll__44_/D u_dll__26_/X VPWR VGND sg13cmos5l_dfrbpq_1
Xu_dll_u_controller_buffer_u_buf u_dll_u_controller_buffer_u_buf/X u_dll_u_div1_buffer_u_buf/A
+ VPWR VGND sg13cmos5l_buf_2
Xu_dll_u_ring_dstage\[0\].id_core_slow_isolation_u_buf u_dll_u_ring_dstage\[0\].id_core_delaymux1_u_a1/A
+ u_dll_u_ring_u_output_inv0_u_inv/A VPWR VGND sg13cmos5l_buf_2
Xu_dll_u_control__1636_ u_dll_u_control__1667_/B u_dll_u_control__1636_/A u_dll_u_control__1636_/B
+ VPWR VGND sg13cmos5l_xor2_1
Xu_dll_u_control__1567_ u_dll_u_control__1567_/Y u_dll_u_control__2151_/Q u_dll_u_control__1567_/B
+ u_dll_u_control__1567_/C VPWR VGND sg13cmos5l_nand3b_1
Xu_dll_u_control__1705_ u_dll_u_control__1706_/B u_dll_u_control__2216_/Q u_dll_u_control__1705_/B
+ VPWR VGND sg13cmos5l_xor2_1
XFILLER_44_249 VPWR VGND sg13cmos5l_fill_2
Xu_dll_u_control__1498_ u_dll_u_control__1499_/C u_dll_u_control__2156_/Q u_dll_u_control__1501_/B
+ VPWR VGND sg13cmos5l_nor2_1
XFILLER_4_323 VPWR VGND sg13cmos5l_decap_8
Xu_dll_u_control__2119_ u_dll_u_control__2119_/Y u_dll_u_control__2119_/A VPWR VGND
+ sg13cmos5l_inv_1
XFILLER_35_238 VPWR VGND sg13cmos5l_fill_2
Xu_dll_u_control__1421_ u_dll_u_control__1421_/Y u_dll_u_control__1451_/B VPWR VGND
+ sg13cmos5l_inv_1
Xu_dll_u_ring_dstage\[5\].id_core_reset_inv_u_inv u_dll_u_ring_dstage\[5\].id_core_reset_inv_u_inv/Y
+ u_dll_u_ring_dstage\[5\].id_const0_u_lo/L_LO VPWR VGND sg13cmos5l_inv_1
XFILLER_41_219 VPWR VGND sg13cmos5l_fill_1
Xu_dll_u_control__1283_ u_dll_u_control__1864_/B u_dll_u_control__1829_/A u_dll_u_control__1684_/B
+ VPWR VGND sg13cmos5l_nand2_1
Xu_dll_u_control__1352_ u_dll_u_control__1362_/B u_dll_u_control__2198_/Q u_dll_u_control__1366_/B
+ VPWR VGND sg13cmos5l_nand2_1
Xu_dll__27_ u_dll__27_/X u_dll__29_/A u_dll__29_/B VPWR VGND sg13cmos5l_and2_1
XFILLER_5_109 VPWR VGND sg13cmos5l_fill_2
XFILLER_1_304 VPWR VGND sg13cmos5l_fill_2
Xu_dll_u_control__1619_ u_dll_u_control__1619_/Y u_dll_u_control__2142_/Q u_dll_u_control__1619_/B
+ VPWR VGND sg13cmos5l_nor2_1
Xclkbuf_3_4_0_u_dll\_controller_ring_clk clkbuf_3_4_0_u_dll\_controller_ring_clk/X
+ clkbuf_3_7_0_u_dll\_controller_ring_clk/A VPWR VGND sg13cmos5l_buf_8
Xu_dll_u_ring_dstage\[4\].id_core_long_gate_u_nand u_dll_u_ring_dstage\[4\].id_core_long_gate_u_nand/Y
+ u_dll_u_ring_dstage\[4\].id_core_long_gate_u_nand/A u_dll_u_ring_dstage\[4\].id_core_long_gate_u_nand/B
+ VPWR VGND sg13cmos5l_nand2_2
XFILLER_27_53 VPWR VGND sg13cmos5l_fill_1
XFILLER_40_285 VPWR VGND sg13cmos5l_decap_8
XFILLER_40_274 VPWR VGND sg13cmos5l_fill_2
XFILLER_4_35 VPWR VGND sg13cmos5l_decap_8
XFILLER_48_363 VPWR VGND sg13cmos5l_decap_8
Xu_dll_u_div1__095_ u_dll_u_div1__095_/Y u_dll_u_div1__103_/Q u_dll_u_div1__105_/Q
+ u_dll_u_div1__104_/Q VPWR VGND sg13cmos5l_nor3_1
Xu_dll_u_control__1970_ u_dll_u_control__1970_/Y u_dll_u_control__2127_/A VPWR VGND
+ sg13cmos5l_inv_1
Xclkbuf_4_10_0_u_dll\_controller_ref_clk clkbuf_4_10_0_u_dll\_controller_ref_clk/X
+ clkbuf_4_9_0_u_dll\_controller_ref_clk/A VPWR VGND sg13cmos5l_buf_8
Xu_dll_u_ring_iss_core_trim_sync\[1\].meta_u_ff u_dll_u_ring_iss_core_trim_sync\[1\].meta_u_ff/Q
+ u_dll_u_ring_iss_core_delayinv1_u_inv/Y u_dll_u_control__1098_/Y u_dll_u_ring_iss_core_trim_reset_inv_u_inv/Y
+ VPWR VGND sg13cmos5l_dfrbpq_1
Xu_dll_u_control__1404_ u_dll_u_control__1404_/Y u_dll_u_control__2184_/Q u_dll_u_control__1410_/B
+ VPWR VGND sg13cmos5l_nand2_1
Xclkbuf_2_3_0_u_dll\_controller_ref_clk clkbuf_2_3_0_u_dll\_controller_ref_clk/X clkbuf_2_3_0_u_dll\_controller_ref_clk/A
+ VPWR VGND sg13cmos5l_buf_8
Xu_dll_u_control__1197_ u_dll_u_control__1230_/A u_dll_u_control__2285_/Q u_dll_u_control__1197_/B
+ VPWR VGND sg13cmos5l_xnor2_1
Xu_dll_u_control__1266_ u_dll_u_control__1850_/B u_dll_u_control__1829_/A u_dll_u_control__1834_/B
+ VPWR VGND sg13cmos5l_nand2_1
Xu_dll_u_control__1335_ u_dll_u_control__1337_/A u_dll_u_control__1332_/B u_dll_u_control__1334_/Y
+ u_dll_u_control__1924_/A1 VPWR VGND sg13cmos5l_a21oi_1
XFILLER_10_403 VPWR VGND sg13cmos5l_fill_1
XFILLER_13_11 VPWR VGND sg13cmos5l_fill_1
XFILLER_22_296 VPWR VGND sg13cmos5l_decap_8
XFILLER_49_149 VPWR VGND sg13cmos5l_decap_4
XFILLER_49_138 VPWR VGND sg13cmos5l_fill_1
XFILLER_8_4 VPWR VGND sg13cmos5l_fill_2
Xu_dll_u_ring_dstage\[5\].id_core_delaymux1_u_merge u_dll_u_ring_dstage\[5\].id_core_long_gate_u_nand/A
+ u_dll_u_ring_dstage\[5\].id_core_delaymux1_u_a0/Y u_dll_u_ring_dstage\[5\].id_core_delaymux1_u_a1/Y
+ VPWR VGND sg13cmos5l_nand2_2
XFILLER_45_377 VPWR VGND sg13cmos5l_decap_8
Xu_dll_u_ring_dstage\[4\].id_core_delaybuf1_u_buf u_dll_u_ring_dstage\[4\].id_core_delayinv1_u_inv/A
+ u_dll_u_ring_dstage\[4\].id_core_delaymux1_u_a1/A VPWR VGND sg13cmos5l_buf_1
XFILLER_9_212 VPWR VGND sg13cmos5l_decap_8
XFILLER_9_278 VPWR VGND sg13cmos5l_fill_2
Xu_dll_u_ring_dstage\[10\].id_const0_u_lo u_dll_u_ring_dstage\[10\].id_const0_u_lo/L_LO
+ VPWR VGND sg13cmos5l_tielo
Xu_dll_u_div1__078_ u_dll_u_div1__084_/C u_dll_u_div1__101_/Q u_dll_u_div1__102_/Q
+ VPWR VGND sg13cmos5l_and2_1
Xu_dll_u_control__1120_ u_dll_u_control__1879_/B u_dll_u_control__1120_/A u_dll_u_control__1120_/B
+ u_dll_u_control__1120_/C VPWR VGND sg13cmos5l_or3_1
XFILLER_36_388 VPWR VGND sg13cmos5l_fill_2
Xu_dll_u_control__1953_ u_dll_u_control__1953_/Y u_dll_u_control__2035_/A VPWR VGND
+ sg13cmos5l_inv_1
Xu_dll_u_control__1884_ u_dll_u_control__1885_/C u_dll_u_control__1884_/A u_dll_u_control__1884_/B
+ u_dll_u_control__1884_/C VPWR VGND sg13cmos5l_nand3_1
Xu_pad0_u_buf analog_0 u_pad0_u_buf/A VPWR VGND sg13cmos5l_buf_8
XFILLER_39_171 VPWR VGND sg13cmos5l_fill_2
XFILLER_27_355 VPWR VGND sg13cmos5l_fill_1
Xu_dll_u_control__1318_ u_dll_u_control__1318_/X u_dll_u_control__1921_/B u_dll_u_control__1385_/B
+ VPWR VGND sg13cmos5l_and2_1
Xu_dll_u_control__1249_ u_dll_u_control__1686_/C u_dll_u_control__1247_/B u_dll_u_control__1246_/B
+ u_dll_u_control__1247_/Y u_dll_u_control__1248_/Y VPWR VGND sg13cmos5l_a22oi_1
XFILLER_6_204 VPWR VGND sg13cmos5l_fill_1
Xu_dll_u_control__2298_ u_dll_u_control__2298_/Q u_dll_u_control__2298_/CLK u_dll_u_control__2298_/D
+ u_dll_u_control__1958_/Y VPWR VGND sg13cmos5l_dfrbpq_1
Xu_dll_u_div0__096_ u_dll_u_div0__097_/C u_dll_u_div0__080_/C u_dll_u_div0__095_/Y
+ u_dll_u_div0__100_/D VPWR VGND sg13cmos5l_a21oi_1
XFILLER_6_259 VPWR VGND sg13cmos5l_decap_8
XFILLER_5_270 VPWR VGND sg13cmos5l_decap_8
Xu_dll_u_control__2152_ u_dll_u_control__2152_/Q u_dll_u_control__2245_/CLK u_dll_u_control__2152_/D
+ u_dll_u_control__2009_/Y VPWR VGND sg13cmos5l_dfrbpq_1
Xu_dll_u_control__2221_ u_dll_u_control__2221_/Q u_dll_u_control__2235_/CLK u_dll_u_control__2221_/D
+ u_dll_u_control__2078_/Y VPWR VGND sg13cmos5l_dfrbpq_1
Xu_dll_u_control__1103_ u_dll_u_control__1619_/B u_dll_u_control__1618_/B VPWR VGND
+ sg13cmos5l_inv_1
Xu_dll_u_ring_dstage\[2\].id_core_merge_gate_u_nand u_dll_u_ring_dstage\[2\].id_core_reset_gate_u_aoi/B1
+ u_dll_u_ring_dstage\[2\].id_core_short_gate_u_nand/Y u_dll_u_ring_dstage\[2\].id_core_long_gate_u_nand/Y
+ u_dll_u_ring_dstage\[2\].id_core_reset_inv_u_inv/Y VPWR VGND sg13cmos5l_nand3_1
Xu_dll_u_control__2083_ u_dll_u_control__2083_/Y u_dll_u_control__2083_/A VPWR VGND
+ sg13cmos5l_inv_1
Xclkbuf_5_7__f_u_dll\_controller_ref_clk u_dll_u_control__2271_/CLK clkbuf_4_3_0_u_dll\_controller_ref_clk/X
+ VPWR VGND sg13cmos5l_buf_8
Xu_dll_u_control__1936_ u_dll_u_control__1936_/Y u_dll_u_control__2102_/A VPWR VGND
+ sg13cmos5l_inv_1
Xu_dll_u_control__1867_ u_dll_u_control__2286_/D u_dll_u_control__1867_/A u_dll_u_control__1876_/A
+ VPWR VGND sg13cmos5l_nor2_1
Xclkbuf_4_1__f_u_dll\_controller_ring_clk u_dll_u_control__2207_/CLK clkbuf_3_0_0_u_dll\_controller_ring_clk/X
+ VPWR VGND sg13cmos5l_buf_8
XFILLER_19_119 VPWR VGND sg13cmos5l_fill_2
Xu_dll_u_control__1798_ u_dll_u_control__1803_/A u_dll_u_control__2160_/Q u_dll_u_control__2320_/Q
+ VPWR VGND sg13cmos5l_nor2b_1
XFILLER_35_97 VPWR VGND sg13cmos5l_fill_1
XFILLER_35_75 VPWR VGND sg13cmos5l_decap_4
Xu_dll_u_div0__079_ u_dll_u_div0__080_/C u_dll_u_div0__101_/Q u_dll_u_div0__102_/Q
+ VPWR VGND sg13cmos5l_nor2_1
XFILLER_2_273 VPWR VGND sg13cmos5l_fill_2
XFILLER_18_6 VPWR VGND sg13cmos5l_fill_1
XFILLER_33_133 VPWR VGND sg13cmos5l_fill_2
Xu_dll_u_control__1721_ u_dll_u_control__2220_/D u_dll_u_control__2220_/Q u_dll_u_control__1741_/A
+ u_dll_u_control__1723_/A u_dll_u_control__1719_/Y u_dll_u_control__1723_/B VPWR
+ VGND sg13cmos5l_a221oi_1
Xu_dll_u_control__1583_ u_dll_u_control__1638_/B u_dll_u_control__2133_/Q u_dll_u_control__2239_/Q
+ VPWR VGND sg13cmos5l_xnor2_1
Xu_dll_u_control__1652_ u_dll_u_control__1653_/B u_dll_u_control__1702_/A u_dll_u_control__1652_/B
+ VPWR VGND sg13cmos5l_nor2_1
Xu_dll_u_control__2135_ u_dll_u_control__2135_/Q u_dll_u_control__2275_/CLK u_dll_u_control__2135_/D
+ u_dll_u_control__1992_/Y VPWR VGND sg13cmos5l_dfrbpq_1
Xu_dll_u_control__2204_ u_dll_u_control__2204_/Q u_dll_u_control__2315_/CLK u_dll_u_control__2204_/D
+ u_dll_u_control__2061_/Y VPWR VGND sg13cmos5l_dfrbpq_1
Xu_dll_u_control__2066_ u_dll_u_control__2066_/Y u_dll_u_control__2090_/A VPWR VGND
+ sg13cmos5l_inv_1
XFILLER_12_339 VPWR VGND sg13cmos5l_fill_1
Xu_dll_u_control__1919_ u_dll_u_control__2309_/D u_dll_u_control__2180_/Q u_dll_u_control__1919_/B
+ VPWR VGND sg13cmos5l_and2_1
Xu_dll_u_resetb_buffer_u_buf u_dll_fanout98/A rst_n VPWR VGND sg13cmos5l_buf_4
Xu_dll_u_ring_trim_reset_buffers\[3\].u_buffer_u_buf u_dll_u_ring_trim_reset_buffers\[3\].u_buffer_u_buf/X
+ u_dll_u_ring_reset_buffer_u_buf/X VPWR VGND sg13cmos5l_buf_4
XFILLER_23_4 VPWR VGND sg13cmos5l_fill_1
XFILLER_38_247 VPWR VGND sg13cmos5l_fill_2
Xu_dll__43_ u_dll__44_/D u_dll__30_/Y u_dll__43_/D u_dll__27_/X VPWR VGND sg13cmos5l_dfrbpq_1
Xclkbuf_4_13_0_u_dll\_controller_ref_clk clkbuf_4_13_0_u_dll\_controller_ref_clk/X
+ clkbuf_2_3_0_u_dll\_controller_ref_clk/X VPWR VGND sg13cmos5l_buf_8
Xu_dll_u_control__1704_ u_dll_u_control__2215_/D u_dll_u_control__1706_/A u_dll_u_control__1704_/B
+ VPWR VGND sg13cmos5l_nor2_1
Xu_dll_u_control__1635_ u_dll_u_control__1636_/B u_dll_u_control__2135_/Q u_dll_u_control__2241_/Q
+ VPWR VGND sg13cmos5l_xor2_1
Xu_dll_u_control__1566_ u_dll_u_control__1566_/Y u_dll_u_control__2152_/Q u_dll_u_control__1719_/B
+ u_dll_u_control__2151_/Q VPWR VGND sg13cmos5l_o21ai_1
Xu_dll_u_ring_dstage\[0\].id_core_short_gate_u_nand u_dll_u_ring_dstage\[0\].id_core_short_gate_u_nand/Y
+ u_dll_u_ring_u_output_inv0_u_inv/A u_dll_u_ring_dstage\[0\].id_core_short_gate_u_nand/B
+ VPWR VGND sg13cmos5l_nand2_1
Xu_dll_u_control__1497_ u_dll_u_control__1499_/B u_dll_u_control__2184_/Q u_dll_u_control__1506_/B
+ VPWR VGND sg13cmos5l_nor2_1
Xu_dll_u_control__2118_ u_dll_u_control__2118_/Y u_dll_u_control__2118_/A VPWR VGND
+ sg13cmos5l_inv_1
XFILLER_4_302 VPWR VGND sg13cmos5l_decap_8
Xu_dll_u_control__2049_ u_dll_u_control__2049_/Y u_dll_u_control__2049_/A VPWR VGND
+ sg13cmos5l_inv_1
XFILLER_4_379 VPWR VGND sg13cmos5l_decap_8
XFILLER_31_401 VPWR VGND sg13cmos5l_fill_2
Xclkbuf_5_18__f_u_dll\_controller_ref_clk u_dll_u_control__2223_/CLK clkbuf_4_9_0_u_dll\_controller_ref_clk/X
+ VPWR VGND sg13cmos5l_buf_8
Xu_dll_u_ring_dstage\[8\].id_core_delaymux1_u_merge u_dll_u_ring_dstage\[8\].id_core_long_gate_u_nand/A
+ u_dll_u_ring_dstage\[8\].id_core_delaymux1_u_a0/Y u_dll_u_ring_dstage\[8\].id_core_delaymux1_u_a1/Y
+ VPWR VGND sg13cmos5l_nand2_2
Xu_dll_u_control__1420_ u_dll_u_control__1451_/B u_dll_u_control__2301_/Q u_dll_u_control__1420_/B
+ VPWR VGND sg13cmos5l_nand2_2
Xu_dll_u_control__1351_ u_dll_u_control__1366_/B u_dll_u_control__1351_/A u_dll_u_control__1370_/B
+ VPWR VGND sg13cmos5l_nor2_1
Xu_dll_u_ring_iss_core_trim_sync\[0\].meta_u_ff u_dll_u_ring_iss_core_trim_sync\[0\].meta_u_ff/Q
+ u_dll_u_ring_iss_core_delayinv1_u_inv/Y u_dll_u_control__2258_/Q u_dll_u_ring_iss_core_trim_reset_inv_u_inv/Y
+ VPWR VGND sg13cmos5l_dfrbpq_1
XFILLER_41_209 VPWR VGND sg13cmos5l_fill_2
Xu_dll_u_control__1282_ u_dll_u_control__1284_/B u_dll_u_control__1846_/B u_dll_u_control__1844_/B
+ VPWR VGND sg13cmos5l_nand2_1
Xu_dll__26_ u_dll__26_/X u_dll__26_/A u_dll__26_/B VPWR VGND sg13cmos5l_and2_1
Xu_dll_u_control__1618_ u_dll_u_control__1652_/B u_dll_u_control__1618_/A u_dll_u_control__1618_/B
+ u_dll_u_control__1618_/C VPWR VGND sg13cmos5l_nand3_1
Xu_dll_u_control__1549_ u_dll_u_control__1550_/D u_dll_u_control__1545_/Y u_dll_u_control__1547_/Y
+ u_dll_u_control__1548_/Y VPWR VGND sg13cmos5l_o21ai_1
Xu_dll_u_ring_dstage\[6\].id_core_delaymux1_u_a0 u_dll_u_ring_dstage\[6\].id_core_delaymux1_u_a0/Y
+ u_dll_u_ring_dstage\[6\].id_core_delaymux1_u_a0/A u_dll_u_ring_dstage\[6\].id_core_delaymux1_u_a0/B
+ VPWR VGND sg13cmos5l_nand2_2
XFILLER_25_283 VPWR VGND sg13cmos5l_fill_1
Xu_dll_u_div1__094_ u_dll_u_div1__097_/B u_dll_u_div1__105_/Q u_dll_u_div1__094_/B
+ u_dll_u_div1__094_/C VPWR VGND sg13cmos5l_nor3_1
XFILLER_0_393 VPWR VGND sg13cmos5l_decap_8
XFILLER_16_250 VPWR VGND sg13cmos5l_fill_2
XFILLER_16_294 VPWR VGND sg13cmos5l_decap_8
Xu_dll_u_ring_dstage\[1\].id_core_fast_decode_u_nor u_dll_u_ring_dstage\[1\].id_core_reset_gate_u_aoi/A2
+ u_dll_u_ring_dstage\[1\].id_core_delaymux1_u_a1/B u_dll_u_ring_dstage\[1\].id_core_long_gate_u_nand/B
+ VPWR VGND sg13cmos5l_nor2_2
Xu_dll_u_ring_dstage\[8\].id_core_reset_gate_u_aoi u_dll_u_ring_dstage\[8\].id_core_reset_gate_u_aoi/Y
+ u_dll_u_ring_dstage\[7\].id_core_reset_gate_u_aoi/Y u_dll_u_ring_dstage\[8\].id_core_reset_gate_u_aoi/A2
+ u_dll_u_ring_dstage\[8\].id_core_reset_gate_u_aoi/B1 VPWR VGND sg13cmos5l_a21oi_2
XFILLER_39_353 VPWR VGND sg13cmos5l_decap_8
Xu_dll_u_control__1334_ u_dll_u_control__1334_/Y u_dll_u_control__1923_/B u_dll_u_control__1334_/B
+ VPWR VGND sg13cmos5l_nand2_1
Xu_dll_u_control__1403_ u_dll_u_control__2185_/D u_dll_u_control__1369_/B u_dll_u_control__1386_/C
+ u_dll_u_control__1402_/Y VPWR VGND sg13cmos5l_o21ai_1
Xu_dll_u_control__1196_ u_dll_u_control__1196_/Y u_dll_u_control__1163_/A u_dll_u_control__1215_/A
+ u_dll_u_control__1195_/X VPWR VGND sg13cmos5l_o21ai_1
Xu_dll_u_control__1265_ u_dll_u_control__1846_/D u_dll_u_control__1851_/A u_dll_u_control__1851_/C
+ VPWR VGND sg13cmos5l_nor2_1
Xu_dll_u_ring_dstage\[5\].id_core_merge_gate_u_nand u_dll_u_ring_dstage\[5\].id_core_reset_gate_u_aoi/B1
+ u_dll_u_ring_dstage\[5\].id_core_short_gate_u_nand/Y u_dll_u_ring_dstage\[5\].id_core_long_gate_u_nand/Y
+ u_dll_u_ring_dstage\[5\].id_core_reset_inv_u_inv/Y VPWR VGND sg13cmos5l_nand3_1
XFILLER_22_275 VPWR VGND sg13cmos5l_decap_8
XFILLER_45_356 VPWR VGND sg13cmos5l_decap_8
XFILLER_9_224 VPWR VGND sg13cmos5l_decap_8
Xu_dll_u_ring_dstage\[6\].id_core_secondary_inv_u_inv u_dll_u_ring_dstage\[6\].id_core_short_decode_u_and/B
+ u_dll_u_ring_dstage\[6\].id_core_long_gate_u_nand/B VPWR VGND sg13cmos5l_inv_1
Xu_dll_u_div1__077_ u_dll_u_div1__101_/D u_dll_u_div1__101_/Q u_dll_u_div1__088_/A
+ VPWR VGND sg13cmos5l_nor2_1
XFILLER_36_345 VPWR VGND sg13cmos5l_fill_1
Xu_dll_u_control__1883_ u_dll_u_control__2278_/D u_dll_u_control__1883_/A u_dll_u_control__1883_/B
+ VPWR VGND sg13cmos5l_nor2_1
Xu_dll_u_control__1952_ u_dll_u_control__1952_/Y u_dll_u_control__2049_/A VPWR VGND
+ sg13cmos5l_inv_1
Xu_dll_u_control__1248_ u_dll_u_control__1248_/Y u_dll_u_control__1153_/Y u_dll_u_control__1228_/A
+ u_dll_u_control__1204_/X VPWR VGND sg13cmos5l_a21oi_1
Xu_dll_u_control__2297_ u_dll_u_control__2297_/Q clkload8/A u_dll_u_control__2297_/D
+ u_dll_u_control__1957_/Y VPWR VGND sg13cmos5l_dfrbpq_1
Xu_dll_u_control__1317_ u_dll_u_control__1385_/B u_dll_u_control__2314_/Q u_dll_u_control__2180_/Q
+ VPWR VGND sg13cmos5l_xnor2_1
Xu_dll_u_div0__095_ u_dll_u_div0__095_/Y u_dll_u_div0__103_/Q u_dll_u_div0__105_/Q
+ u_dll_u_div0__104_/Q VPWR VGND sg13cmos5l_nor3_1
Xu_dll_u_control__1179_ u_dll_u_control__1180_/B u_dll_u_control__2285_/Q u_dll_u_control__1197_/B
+ VPWR VGND sg13cmos5l_nor2_1
XFILLER_6_238 VPWR VGND sg13cmos5l_decap_8
XFILLER_10_212 VPWR VGND sg13cmos5l_decap_8
XFILLER_24_77 VPWR VGND sg13cmos5l_fill_2
XFILLER_40_76 VPWR VGND sg13cmos5l_fill_1
Xu_dll_u_ring_dstage\[6\].id_core_trim_sync\[1\].meta_u_ff u_dll_u_ring_dstage\[6\].id_core_trim_sync\[1\].meta_u_ff/Q
+ u_dll_u_ring_dstage\[6\].id_core_delayinv1_u_inv/Y u_dll_u_control__1072_/Y u_dll_u_ring_dstage\[6\].id_core_trim_reset_inv_u_inv/Y
+ VPWR VGND sg13cmos5l_dfrbpq_1
XFILLER_49_96 VPWR VGND sg13cmos5l_fill_1
XFILLER_49_74 VPWR VGND sg13cmos5l_fill_2
XFILLER_1_15 VPWR VGND sg13cmos5l_decap_4
Xu_dll_u_control__2151_ u_dll_u_control__2151_/Q clkload6/A u_dll_u_control__2151_/D
+ u_dll_u_control__2008_/Y VPWR VGND sg13cmos5l_dfrbpq_1
XFILLER_36_153 VPWR VGND sg13cmos5l_fill_1
Xu_dll_u_control__2220_ u_dll_u_control__2220_/Q clkload6/A u_dll_u_control__2220_/D
+ u_dll_u_control__2077_/Y VPWR VGND sg13cmos5l_dfrbpq_1
Xu_dll_u_control__1102_ u_dll_u_control__1690_/D u_dll_u_control__2093_/A VPWR VGND
+ sg13cmos5l_inv_1
Xu_dll_u_control__2082_ u_dll_u_control__2082_/Y u_dll_u_control__2082_/A VPWR VGND
+ sg13cmos5l_inv_1
Xu_dll_u_control__1935_ u_dll_u_control__1935_/Y u_dll_u_control__2102_/A VPWR VGND
+ sg13cmos5l_inv_1
Xu_dll_u_control__1866_ u_dll_u_control__2246_/D u_dll_u_control__1859_/B u_dll_u_control__1844_/C
+ u_dll_u_control__1837_/Y u_dll_u_control__1863_/B u_dll_u_control__1859_/Y VPWR
+ VGND sg13cmos5l_a221oi_1
XFILLER_19_11 VPWR VGND sg13cmos5l_decap_4
Xu_dll_u_control__1797_ u_dll_u_control__2230_/D u_dll_u_control__2159_/Q u_dll_u_control__1797_/B
+ VPWR VGND sg13cmos5l_and2_1
XFILLER_30_307 VPWR VGND sg13cmos5l_fill_1
Xu_dll_u_ring_dstage\[3\].id_core_short_gate_u_nand u_dll_u_ring_dstage\[3\].id_core_short_gate_u_nand/Y
+ u_dll_u_ring_dstage\[2\].id_core_reset_gate_u_aoi/Y u_dll_u_ring_dstage\[3\].id_core_short_gate_u_nand/B
+ VPWR VGND sg13cmos5l_nand2_1
Xu_dll_u_ring_dstage\[1\].id_core_slow_isolation_u_buf u_dll_u_ring_dstage\[1\].id_core_delaymux1_u_a1/A
+ u_dll_u_ring_dstage\[0\].id_core_reset_gate_u_aoi/Y VPWR VGND sg13cmos5l_buf_2
Xu_dll_u_div0__078_ u_dll_u_div0__084_/C u_dll_u_div0__101_/Q u_dll_u_div0__102_/Q
+ VPWR VGND sg13cmos5l_and2_1
Xu_dll_u_div0_reset_buffer_u_buf u_dll_u_div0__105_/RESET_B u_dll__44_/Q VPWR VGND
+ sg13cmos5l_buf_4
XFILLER_44_0 VPWR VGND sg13cmos5l_decap_4
Xu_dll_u_control__1651_ u_dll_u_control__1651_/Y u_dll_u_control__1643_/A u_dll_u_control__1657_/B
+ VPWR VGND sg13cmos5l_nand2b_1
Xu_dll_u_control__1720_ u_dll_u_control__1723_/B u_dll_u_control__2218_/Q u_dll_u_control__2219_/Q
+ u_dll_u_control__2220_/Q VPWR VGND sg13cmos5l_a21oi_1
Xu_dll_u_control__1582_ u_dll_u_control__1638_/A u_dll_u_control__2132_/Q u_dll_u_control__2238_/Q
+ VPWR VGND sg13cmos5l_nand2_1
Xu_dll_u_control__2134_ u_dll_u_control__2134_/Q u_dll_u_control__2274_/CLK u_dll_u_control__2134_/D
+ u_dll_u_control__1991_/Y VPWR VGND sg13cmos5l_dfrbpq_1
Xu_dll_u_control__2065_ u_dll_u_control__2065_/Y u_dll_u_control__2105_/A VPWR VGND
+ sg13cmos5l_inv_1
Xu_dll_u_control__2203_ u_dll_u_control__2203_/Q u_dll_u_control__2319_/CLK u_dll_u_control__2203_/D
+ u_dll_u_control__2060_/Y VPWR VGND sg13cmos5l_dfrbpq_1
XFILLER_24_123 VPWR VGND sg13cmos5l_fill_1
Xu_dll_u_control__1849_ u_dll_u_control__1864_/C u_dll_u_control__1841_/C u_dll_u_control__1849_/B
+ u_dll_u_control__1867_/A VPWR VGND sg13cmos5l_nand3b_1
Xu_dll_u_control__1918_ u_dll_u_control__2310_/D u_dll_u_control__1919_/B u_dll_u_control__2309_/Q
+ VPWR VGND sg13cmos5l_and2_1
XFILLER_30_148 VPWR VGND sg13cmos5l_fill_1
Xu_dll_u_ring_dstage\[1\].id_const0_u_hi u_dll_u_ring_dstage\[1\].id_const0_u_hi/L_HI
+ VPWR VGND sg13cmos5l_tiehi
XFILLER_7_399 VPWR VGND sg13cmos5l_decap_4
Xu_dll_u_div1_u_clkbuf_count_u_buf u_dll_u_div1__056_/A u_dll_u_div1_buffer_u_buf/X
+ VPWR VGND sg13cmos5l_buf_4
XFILLER_16_4 VPWR VGND sg13cmos5l_fill_2
Xu_dll__42_ u_dll__43_/D u_dll__18_/Y u_dll__42_/D u_dll__28_/X VPWR VGND sg13cmos5l_dfrbpq_1
Xu_dll_u_ring_dstage\[4\].id_core_fast_decode_u_nor u_dll_u_ring_dstage\[4\].id_core_reset_gate_u_aoi/A2
+ u_dll_u_ring_dstage\[4\].id_core_delaymux1_u_a1/B u_dll_u_ring_dstage\[4\].id_core_long_gate_u_nand/B
+ VPWR VGND sg13cmos5l_nor2_2
Xu_dll_u_control__1634_ u_dll_u_control__1665_/B u_dll_u_control__1588_/Y u_dll_u_control__1634_/B
+ VPWR VGND sg13cmos5l_nand2b_1
Xu_dll_u_control__1703_ u_dll_u_control__1704_/B u_dll_u_control__2215_/Q u_dll_u_control__1703_/B
+ VPWR VGND sg13cmos5l_xor2_1
XFILLER_44_207 VPWR VGND sg13cmos5l_fill_2
Xu_dll_u_control__1565_ u_dll_u_control__2152_/D u_dll_u_control__1565_/A u_dll_u_control__1565_/B
+ VPWR VGND sg13cmos5l_nor2_1
XFILLER_16_23 VPWR VGND sg13cmos5l_decap_8
Xu_dll_u_control__1496_ u_dll_u_control__2157_/D u_dll_u_control__1508_/A u_dll_u_control__1496_/B
+ u_dll_u_control__1496_/C VPWR VGND sg13cmos5l_nor3_1
Xu_dll_u_control__2117_ u_dll_u_control__2117_/Y u_dll_u_control__2125_/A VPWR VGND
+ sg13cmos5l_inv_1
Xu_dll_u_control__2048_ u_dll_u_control__2048_/Y u_dll_u_control__2048_/A VPWR VGND
+ sg13cmos5l_inv_1
XFILLER_4_358 VPWR VGND sg13cmos5l_decap_8
Xu_fabric1_u_buf uo_out[1] u_pad1_u_buf/A VPWR VGND sg13cmos5l_buf_8
Xu_dll_u_ring_dstage\[8\].id_core_merge_gate_u_nand u_dll_u_ring_dstage\[8\].id_core_reset_gate_u_aoi/B1
+ u_dll_u_ring_dstage\[8\].id_core_short_gate_u_nand/Y u_dll_u_ring_dstage\[8\].id_core_long_gate_u_nand/Y
+ u_dll_u_ring_dstage\[8\].id_core_reset_inv_u_inv/Y VPWR VGND sg13cmos5l_nand3_1
XFILLER_43_273 VPWR VGND sg13cmos5l_fill_1
XFILLER_43_262 VPWR VGND sg13cmos5l_decap_4
Xclkbuf_5_24__f_u_dll\_controller_ref_clk u_dll_u_control__2245_/CLK clkbuf_4_12_0_u_dll\_controller_ref_clk/X
+ VPWR VGND sg13cmos5l_buf_8
Xu_dll_u_control__1350_ u_dll_u_control__1370_/B u_dll_u_control__2196_/Q u_dll_u_control__2195_/Q
+ u_dll_u_control__2194_/Q VPWR VGND sg13cmos5l_nand3_1
Xu_dll_u_control__1281_ u_dll_u_control__1281_/Y u_dll_u_control__1686_/C u_dll_u_control__1849_/B
+ VPWR VGND sg13cmos5l_nor2_1
Xu_dll__25_ u_dll__25_/X u_dll__26_/A u_dll__26_/B VPWR VGND sg13cmos5l_and2_1
Xu_dll_u_div0_u_parity_mux_u_merge u_dll_u_div0_u_valid_gate_u_and/A u_dll_u_div0_u_parity_mux_u_a0/Y
+ u_dll_u_div0_u_parity_mux_u_a1/Y VPWR VGND sg13cmos5l_nand2_2
Xu_dll_u_ring_dstage\[10\].id_core_trim_reset_inv_u_inv u_dll_u_ring_dstage\[10\].id_core_trim_reset_inv_u_inv/Y
+ u_dll_u_ring_trim_reset_buffers\[3\].u_buffer_u_buf/X VPWR VGND sg13cmos5l_inv_2
Xu_dll_u_control__1617_ u_dll_u_control__2145_/D u_dll_u_control__1618_/A u_dll_u_control__1653_/A
+ u_dll_u_control__1616_/Y VPWR VGND sg13cmos5l_a21o_1
Xu_dll_u_control__1548_ u_dll_u_control__1548_/Y u_dll_u_control__1742_/A u_dll_u_control__1730_/B
+ VPWR VGND sg13cmos5l_nand2_1
XFILLER_13_402 VPWR VGND sg13cmos5l_fill_2
Xu_dll_u_control__1479_ u_dll_u_control__1481_/B u_dll_u_control__2190_/Q u_dll_u_control__1485_/B
+ VPWR VGND sg13cmos5l_nor2_1
XFILLER_27_44 VPWR VGND sg13cmos5l_decap_4
XFILLER_27_66 VPWR VGND sg13cmos5l_decap_8
XFILLER_40_298 VPWR VGND sg13cmos5l_fill_1
Xu_dll_u_ring_dstage\[6\].id_core_delaymux1_u_a1 u_dll_u_ring_dstage\[6\].id_core_delaymux1_u_a1/Y
+ u_dll_u_ring_dstage\[6\].id_core_delaymux1_u_a1/A u_dll_u_ring_dstage\[6\].id_core_delaymux1_u_a1/B
+ VPWR VGND sg13cmos5l_nand2_2
XFILLER_4_48 VPWR VGND sg13cmos5l_fill_2
XFILLER_48_398 VPWR VGND sg13cmos5l_decap_4
Xu_dll_u_div1__093_ u_dll_u_div1__094_/C u_dll_u_div1__093_/A u_dll_u_div1__093_/B
+ u_dll_u_div1__093_/C VPWR VGND sg13cmos5l_nand3_1
XFILLER_0_372 VPWR VGND sg13cmos5l_decap_8
Xu_dll_u_control__1264_ u_dll_u_control__1827_/B u_dll_u_control__1247_/B u_dll_u_control__1246_/B
+ u_dll_u_control__1247_/Y u_dll_u_control__1248_/Y u_dll_u_control__1844_/B VPWR
+ VGND sg13cmos5l_a221oi_1
Xu_dll_u_control__1333_ u_dll_u_control__2206_/D u_dll_u_control__1327_/Y u_dll_u_control__1386_/B
+ u_dll_u_control__1326_/Y VPWR VGND sg13cmos5l_o21ai_1
Xu_dll_u_control__1402_ u_dll_u_control__1402_/Y u_dll_u_control__2185_/Q u_dll_u_control__1410_/B
+ VPWR VGND sg13cmos5l_nand2_1
Xu_dll_u_control__1195_ u_dll_u_control__1195_/X u_dll_u_control__1147_/B u_dll_u_control__1147_/C
+ u_dll_u_control__1207_/A VPWR VGND sg13cmos5l_a21o_1
Xu_dll_u_ring_dstage\[6\].id_core_trim_sync\[0\].meta_u_ff u_dll_u_ring_dstage\[6\].id_core_trim_sync\[0\].meta_u_ff/Q
+ u_dll_u_ring_dstage\[6\].id_core_delayinv1_u_inv/Y u_dll_u_control__2252_/Q u_dll_u_ring_dstage\[6\].id_core_trim_reset_inv_u_inv/Y
+ VPWR VGND sg13cmos5l_dfrbpq_1
XFILLER_22_254 VPWR VGND sg13cmos5l_decap_8
XFILLER_8_6 VPWR VGND sg13cmos5l_fill_1
Xu_dll_u_ring_dstage\[9\].id_core_long_gate_u_nand u_dll_u_ring_dstage\[9\].id_core_long_gate_u_nand/Y
+ u_dll_u_ring_dstage\[9\].id_core_long_gate_u_nand/A u_dll_u_ring_dstage\[9\].id_core_long_gate_u_nand/B
+ VPWR VGND sg13cmos5l_nand2_2
XFILLER_45_313 VPWR VGND sg13cmos5l_fill_1
XFILLER_38_76 VPWR VGND sg13cmos5l_fill_2
Xu_dll_u_ring_dstage\[1\].id_core_trim_sync\[1\].meta_u_ff u_dll_u_ring_dstage\[1\].id_core_trim_sync\[1\].meta_u_ff/Q
+ u_dll_u_ring_dstage\[1\].id_core_delayinv1_u_inv/Y u_dll_u_control__1077_/Y u_dll_u_ring_dstage\[1\].id_core_trim_reset_inv_u_inv/Y
+ VPWR VGND sg13cmos5l_dfrbpq_1
Xu_dll_u_ring_dstage\[6\].id_const0_u_hi u_dll_u_ring_dstage\[6\].id_const0_u_hi/L_HI
+ VPWR VGND sg13cmos5l_tiehi
Xu_dll_u_ring_dstage\[6\].id_core_short_gate_u_nand u_dll_u_ring_dstage\[6\].id_core_short_gate_u_nand/Y
+ u_dll_u_ring_dstage\[5\].id_core_reset_gate_u_aoi/Y u_dll_u_ring_dstage\[6\].id_core_short_gate_u_nand/B
+ VPWR VGND sg13cmos5l_nand2_1
Xclkbuf_1_0_0_u_dll\_controller_ring_clk clkbuf_3_3_0_u_dll\_controller_ring_clk/A
+ clkbuf_0_u_dll\_controller_ring_clk/X VPWR VGND sg13cmos5l_buf_8
Xu_dll_u_div1__076_ u_dll_u_div1__088_/A u_dll_u_div1__071_/Y u_dll_u_div1__074_/Y
+ u_dll_u_div1__075_/Y VPWR VGND sg13cmos5l_o21ai_1
XFILLER_36_302 VPWR VGND sg13cmos5l_fill_2
Xu_dll_u_ring_dstage\[4\].id_core_delayint0_u_inv u_dll_u_ring_dstage\[4\].id_core_delaymux1_u_a0/A
+ u_dll_u_ring_dstage\[4\].id_core_delayinv1_u_inv/Y VPWR VGND sg13cmos5l_inv_1
Xu_dll_u_control__1882_ u_dll_u_control__1883_/B u_dll_u_control__1884_/B u_dll_u_control__1885_/B
+ VPWR VGND sg13cmos5l_nand2_1
Xu_dll_u_control__1951_ u_dll_u_control__1951_/Y u_dll_u_control__2049_/A VPWR VGND
+ sg13cmos5l_inv_1
XFILLER_27_335 VPWR VGND sg13cmos5l_decap_4
Xu_dll_u_ring_dstage\[10\].id_core_reset_gate_u_aoi u_dll_u_ring_dstage\[10\].id_core_reset_gate_u_aoi/Y
+ u_dll_u_ring_dstage\[9\].id_core_reset_gate_u_aoi/Y u_dll_u_ring_dstage\[10\].id_core_reset_gate_u_aoi/A2
+ u_dll_u_ring_dstage\[10\].id_core_reset_gate_u_aoi/B1 VPWR VGND sg13cmos5l_a21oi_2
Xu_dll_u_control__1247_ u_dll_u_control__1247_/Y u_dll_u_control__1247_/A u_dll_u_control__1247_/B
+ VPWR VGND sg13cmos5l_nand2_1
Xu_dll_u_control__2296_ u_dll_u_control__2296_/Q u_dll_u_control__2296_/CLK u_dll_u_control__2296_/D
+ u_dll_u_control__1956_/Y VPWR VGND sg13cmos5l_dfrbpq_1
Xu_dll_u_control__1316_ u_dll_u_control__2217_/D u_dll_u_control__1316_/A VPWR VGND
+ sg13cmos5l_inv_1
Xu_dll_u_div0__094_ u_dll_u_div0__097_/B u_dll_u_div0__105_/Q u_dll_u_div0__094_/B
+ u_dll_u_div0__094_/C VPWR VGND sg13cmos5l_nor3_1
Xu_dll_u_control__1178_ u_dll_u_control__1197_/B u_dll_u_control__2283_/Q u_dll_u_control__2284_/Q
+ u_dll_u_control__1189_/B VPWR VGND sg13cmos5l_nand3_1
Xu_dll_u_ring_dstage\[10\].id_core_trim_sync\[1\].meta_u_ff u_dll_u_ring_dstage\[10\].id_core_trim_sync\[1\].meta_u_ff/Q
+ u_dll_u_ring_dstage\[10\].id_core_delayinv1_u_inv/Y u_dll_u_control__1068_/Y u_dll_u_ring_dstage\[10\].id_core_trim_reset_inv_u_inv/Y
+ VPWR VGND sg13cmos5l_dfrbpq_1
Xu_dll_u_div1__059_ u_dll_u_div1__062_/B u_dll_u_div1__106_/Q u_dll_u_div1__107_/Q
+ VPWR VGND sg13cmos5l_nor2b_1
Xu_dll_u_control__2081_ u_dll_u_control__2081_/Y u_dll_u_control__2082_/A VPWR VGND
+ sg13cmos5l_inv_1
Xu_dll_u_control__2150_ u_dll_u_control__2150_/Q u_dll_u_control__2322_/CLK u_dll_u_control__2150_/D
+ u_dll_u_control__2007_/Y VPWR VGND sg13cmos5l_dfrbpq_1
Xu_dll_u_control__1101_ u_dll_u_control__1445_/C u_dll_u_control__2301_/Q VPWR VGND
+ sg13cmos5l_inv_1
XFILLER_32_393 VPWR VGND sg13cmos5l_decap_8
Xu_dll_u_control__1934_ u_dll_u_control__1934_/Y u_dll_u_control__2095_/A VPWR VGND
+ sg13cmos5l_inv_1
Xu_dll_u_ring_dstage\[7\].id_core_fast_decode_u_nor u_dll_u_ring_dstage\[7\].id_core_reset_gate_u_aoi/A2
+ u_dll_u_ring_dstage\[7\].id_core_delaymux1_u_a1/B u_dll_u_ring_dstage\[7\].id_core_long_gate_u_nand/B
+ VPWR VGND sg13cmos5l_nor2_2
Xu_dll_u_control__1796_ u_dll_u_control__2229_/D u_dll_u_control__2158_/Q u_dll_u_control__1797_/B
+ VPWR VGND sg13cmos5l_and2_1
Xu_dll_u_control__1865_ u_dll_u_control__2258_/D u_dll_u_control__1837_/Y u_dll_u_control__1863_/X
+ u_dll_u_control__1864_/X u_dll_u_control__1855_/B VPWR VGND sg13cmos5l_a22oi_1
Xu_dll_u_control__2279_ u_dll_u_control__2279_/Q u_dll_u_control__2279_/CLK u_dll_u_control__2279_/D
+ u_dll_u_control__1939_/Y VPWR VGND sg13cmos5l_dfrbpq_1
Xu_dll_u_div0__077_ u_dll_u_div0__101_/D u_dll_u_div0__101_/Q u_dll_u_div0__088_/A
+ VPWR VGND sg13cmos5l_nor2_1
Xclkbuf_4_2_0_u_dll\_controller_ref_clk clkbuf_4_2_0_u_dll\_controller_ref_clk/X clkbuf_4_3_0_u_dll\_controller_ref_clk/A
+ VPWR VGND sg13cmos5l_buf_8
Xu_dll_u_control__1650_ u_dll_u_control__2143_/D u_dll_u_control__2143_/Q u_dll_u_control__1653_/A
+ u_dll_u_control__1649_/Y VPWR VGND sg13cmos5l_a21o_1
Xu_dll_u_control__1581_ u_dll_u_control__1581_/Y u_dll_u_control__2133_/Q u_dll_u_control__2239_/Q
+ VPWR VGND sg13cmos5l_nand2_1
Xu_dll_u_control__2202_ u_dll_u_control__2202_/Q u_dll_u_control__2319_/CLK u_dll_u_control__2202_/D
+ u_dll_u_control__2059_/Y VPWR VGND sg13cmos5l_dfrbpq_1
Xu_dll_u_control__2133_ u_dll_u_control__2133_/Q u_dll_u_control__2274_/CLK u_dll_u_control__2133_/D
+ u_dll_u_control__1990_/Y VPWR VGND sg13cmos5l_dfrbpq_1
Xu_dll_u_control__2064_ u_dll_u_control__2064_/Y u_dll_u_control__2064_/A VPWR VGND
+ sg13cmos5l_inv_1
Xu_dll_u_control__1917_ u_dll_u_control__2304_/D u_dll_u_control__1899_/B u_dll_u_control__1910_/A
+ u_dll_u_control__1916_/Y VPWR VGND sg13cmos5l_a21oi_1
XFILLER_21_57 VPWR VGND sg13cmos5l_fill_1
Xu_dll_u_control__1779_ u_dll_u_control__2242_/D u_dll_u_control__1784_/A u_dll_u_control__1777_/Y
+ u_dll_u_control__1778_/Y VPWR VGND sg13cmos5l_a21oi_1
Xu_dll_u_control__1848_ u_dll_u_control__2253_/D u_dll_u_control__1848_/A u_dll_u_control__1848_/B
+ u_dll_u_control__1848_/C VPWR VGND sg13cmos5l_and3_1
XFILLER_43_400 VPWR VGND sg13cmos5l_decap_4
Xu_dll_u_ring_dstage\[3\].id_core_short_decode_u_and u_dll_u_ring_dstage\[3\].id_core_short_gate_u_nand/B
+ u_dll_u_ring_dstage\[3\].id_core_delaymux1_u_a1/B u_dll_u_ring_dstage\[3\].id_core_short_decode_u_and/B
+ VPWR VGND sg13cmos5l_and2_2
XFILLER_11_352 VPWR VGND sg13cmos5l_fill_2
XFILLER_23_190 VPWR VGND sg13cmos5l_fill_1
Xu_dll__41_ u_dll__42_/D u_dll__36_/Y u_dll__41_/D u_dll__19_/X VPWR VGND sg13cmos5l_dfrbpq_1
Xu_dll_u_control__1633_ u_dll_u_control__1634_/B u_dll_u_control__1588_/B u_dll_u_control__1588_/C
+ u_dll_u_control__1588_/A VPWR VGND sg13cmos5l_o21ai_1
Xu_dll_u_control__1564_ u_dll_u_control__1565_/B u_dll_u_control__2151_/Q u_dll_u_control__1567_/B
+ u_dll_u_control__2152_/Q VPWR VGND sg13cmos5l_a21oi_1
Xu_dll_u_control__1702_ u_dll_u_control__2214_/D u_dll_u_control__1702_/A u_dll_u_control__1702_/B
+ VPWR VGND sg13cmos5l_nor2_1
Xu_dll_u_control__1495_ u_dll_u_control__1496_/C u_dll_u_control__2157_/Q u_dll_u_control__1501_/B
+ VPWR VGND sg13cmos5l_nor2_1
XFILLER_40_403 VPWR VGND sg13cmos5l_fill_1
Xu_dll_u_control__2047_ u_dll_u_control__2047_/Y u_dll_u_control__2064_/A VPWR VGND
+ sg13cmos5l_inv_1
Xu_dll_u_control__2116_ u_dll_u_control__2116_/Y u_dll_u_control__2118_/A VPWR VGND
+ sg13cmos5l_inv_1
XFILLER_4_337 VPWR VGND sg13cmos5l_decap_8
XFILLER_31_403 VPWR VGND sg13cmos5l_fill_1
Xu_dll_u_ring_dstage\[9\].id_core_short_gate_u_nand u_dll_u_ring_dstage\[9\].id_core_short_gate_u_nand/Y
+ u_dll_u_ring_dstage\[8\].id_core_reset_gate_u_aoi/Y u_dll_u_ring_dstage\[9\].id_core_short_gate_u_nand/B
+ VPWR VGND sg13cmos5l_nand2_1
Xu_dll_u_ring_dstage\[8\].id_core_trim_sync\[1\].applied_u_ff u_dll_u_ring_dstage\[8\].id_core_long_gate_u_nand/B
+ u_dll_u_ring_dstage\[8\].id_core_delayinv1_u_inv/Y u_dll_u_ring_dstage\[8\].id_core_trim_sync\[1\].meta_u_ff/Q
+ u_dll_u_ring_dstage\[8\].id_core_trim_reset_inv_u_inv/Y VPWR VGND sg13cmos5l_dfrbpq_1
Xu_dll_u_control__1280_ u_dll_u_control__2266_/D u_dll_u_control__1280_/A VPWR VGND
+ sg13cmos5l_inv_1
Xu_dll__24_ u_dll__24_/X u_dll__26_/A u_dll__26_/B VPWR VGND sg13cmos5l_and2_1
Xclkbuf_5_30__f_u_dll\_controller_ref_clk u_dll_u_control__2277_/CLK clkbuf_4_15_0_u_dll\_controller_ref_clk/X
+ VPWR VGND sg13cmos5l_buf_8
Xu_dll_u_control__1616_ u_dll_u_control__1616_/Y u_dll_u_control__1702_/A u_dll_u_control__1616_/B
+ u_dll_u_control__1616_/C u_dll_u_control__1661_/A VPWR VGND sg13cmos5l_nor4_1
Xu_dll_u_control__1547_ u_dll_u_control__1547_/Y u_dll_u_control__1742_/A u_dll_u_control__1730_/B
+ u_dll_u_control__1546_/Y VPWR VGND sg13cmos5l_o21ai_1
XFILLER_17_208 VPWR VGND sg13cmos5l_fill_1
Xu_dll_u_ring_dstage\[1\].id_core_trim_sync\[0\].meta_u_ff u_dll_u_ring_dstage\[1\].id_core_trim_sync\[0\].meta_u_ff/Q
+ u_dll_u_ring_dstage\[1\].id_core_delayinv1_u_inv/Y u_dll_u_control__2247_/Q u_dll_u_ring_dstage\[1\].id_core_trim_reset_inv_u_inv/Y
+ VPWR VGND sg13cmos5l_dfrbpq_1
XFILLER_40_233 VPWR VGND sg13cmos5l_fill_1
Xu_dll_u_control__1478_ u_dll_u_control__2163_/D u_dll_u_control__1487_/A u_dll_u_control__1478_/B
+ u_dll_u_control__1478_/C VPWR VGND sg13cmos5l_nor3_1
XFILLER_48_377 VPWR VGND sg13cmos5l_decap_8
Xu_dll_u_div1__092_ u_dll_u_div1__093_/C u_dll_u_div1__110_/Q u_dll_u_div1__104_/Q
+ VPWR VGND sg13cmos5l_xnor2_1
Xu_dll_u_control__1401_ u_dll_u_control__2186_/D u_dll_u_control__1365_/B u_dll_u_control__1386_/C
+ u_dll_u_control__1400_/Y VPWR VGND sg13cmos5l_o21ai_1
Xu_dll_u_control__1194_ u_dll_u_control__1215_/A u_dll_u_control__1197_/B u_dll_u_control__1194_/B
+ VPWR VGND sg13cmos5l_nand2_1
Xu_fabric0_u_buf uo_out[0] u_pad0_u_buf/A VPWR VGND sg13cmos5l_buf_8
Xu_dll_u_control__1332_ u_dll_u_control__1386_/B u_dll_u_control__2206_/Q u_dll_u_control__1332_/B
+ VPWR VGND sg13cmos5l_xor2_1
XFILLER_22_233 VPWR VGND sg13cmos5l_decap_8
Xu_dll_u_control__1263_ u_dll_u_control__2269_/D u_dll_u_control__2261_/D u_dll_u_control__1263_/B
+ VPWR VGND sg13cmos5l_nand2b_1
XFILLER_45_303 VPWR VGND sg13cmos5l_decap_4
Xu_dll_u_ring_dstage\[11\].id_core_delaymux1_u_a0 u_dll_u_ring_dstage\[11\].id_core_delaymux1_u_a0/Y
+ u_dll_u_ring_dstage\[11\].id_core_delaymux1_u_a0/A u_dll_u_ring_dstage\[11\].id_core_delaymux1_u_a0/B
+ VPWR VGND sg13cmos5l_nand2_2
XFILLER_13_299 VPWR VGND sg13cmos5l_fill_2
Xu_dll_u_ring_iss_core_trim_reset_inv_u_inv u_dll_u_ring_iss_core_trim_reset_inv_u_inv/Y
+ u_dll_u_ring_reset_buffer_u_buf/X VPWR VGND sg13cmos5l_inv_2
Xu_dll_u_ring_dstage\[5\].id_core_delayinv1_u_inv u_dll_u_ring_dstage\[5\].id_core_delayinv1_u_inv/Y
+ u_dll_u_ring_dstage\[5\].id_core_delayinv1_u_inv/A VPWR VGND sg13cmos5l_inv_2
Xu_dll_u_ring_dstage\[10\].id_core_trim_sync\[0\].meta_u_ff u_dll_u_ring_dstage\[10\].id_core_trim_sync\[0\].meta_u_ff/Q
+ u_dll_u_ring_dstage\[10\].id_core_delayinv1_u_inv/Y u_dll_u_control__2256_/Q u_dll_u_ring_dstage\[10\].id_core_trim_reset_inv_u_inv/Y
+ VPWR VGND sg13cmos5l_dfrbpq_1
Xheichips26_multimode_dll_small_120 uo_out[6] VPWR VGND sg13cmos5l_tielo
Xu_dll_u_div1__075_ u_dll_u_div1__075_/Y u_dll_u_div1__105_/Q u_dll_u_div1__072_/Y
+ u_dll_u_div1__097_/A VPWR VGND sg13cmos5l_a21oi_1
XFILLER_36_314 VPWR VGND sg13cmos5l_decap_8
Xu_dll_u_control__1950_ u_dll_u_control__1950_/Y u_dll_u_control__2035_/A VPWR VGND
+ sg13cmos5l_inv_1
Xu_dll_u_ring_dstage\[2\].id_core_slow_isolation_u_buf u_dll_u_ring_dstage\[2\].id_core_delaymux1_u_a1/A
+ u_dll_u_ring_dstage\[1\].id_core_reset_gate_u_aoi/Y VPWR VGND sg13cmos5l_buf_2
Xu_dll_u_control__1881_ u_dll_u_control__1883_/A u_dll_u_control__1881_/A u_dll_u_control__1881_/B
+ u_dll_u_control__1881_/C VPWR VGND sg13cmos5l_nor3_1
Xclkbuf_4_5_0_u_dll\_controller_ref_clk clkbuf_4_5_0_u_dll\_controller_ref_clk/X clkbuf_4_7_0_u_dll\_controller_ref_clk/A
+ VPWR VGND sg13cmos5l_buf_8
XFILLER_39_196 VPWR VGND sg13cmos5l_decap_4
Xclkbuf_4_12__f_u_dll\_controller_ring_clk u_dll_u_control__2300_/CLK clkbuf_3_6_0_u_dll\_controller_ring_clk/X
+ VPWR VGND sg13cmos5l_buf_8
Xu_dll_u_control__1177_ u_dll_u_control__1189_/B u_dll_u_control__2282_/Q u_dll_u_control__2281_/Q
+ u_dll_u_control__1183_/A VPWR VGND sg13cmos5l_nor3_1
Xu_dll_u_control__1246_ u_dll_u_control__1246_/X u_dll_u_control__1247_/B u_dll_u_control__1246_/B
+ VPWR VGND sg13cmos5l_and2_1
Xu_dll_u_control__1315_ u_dll_u_control__1316_/A u_dll_u_control__2217_/Q u_dll_u_control__1465_/B
+ u_dll_u_control__1716_/C VPWR VGND sg13cmos5l_o21ai_1
Xu_dll_u_control__2295_ u_dll_u_control__2295_/Q clkload8/A u_dll_u_control__2295_/D
+ u_dll_u_control__1955_/Y VPWR VGND sg13cmos5l_dfrbpq_1
Xu_dll_u_div0__093_ u_dll_u_div0__094_/C u_dll_u_div0__093_/A u_dll_u_div0__093_/B
+ u_dll_u_div0__093_/C VPWR VGND sg13cmos5l_nand3_1
XFILLER_2_402 VPWR VGND sg13cmos5l_fill_2
XFILLER_49_87 VPWR VGND sg13cmos5l_decap_8
Xu_dll_u_ring_dstage\[11\].id_core_long_gate_u_nand u_dll_u_ring_dstage\[11\].id_core_long_gate_u_nand/Y
+ u_dll_u_ring_dstage\[11\].id_core_long_gate_u_nand/A u_dll_u_ring_dstage\[11\].id_core_long_gate_u_nand/B
+ VPWR VGND sg13cmos5l_nand2_2
XFILLER_45_111 VPWR VGND sg13cmos5l_fill_1
XFILLER_33_317 VPWR VGND sg13cmos5l_decap_8
XFILLER_5_284 VPWR VGND sg13cmos5l_decap_4
XFILLER_36_133 VPWR VGND sg13cmos5l_fill_1
Xu_dll_u_div1__058_ u_dll_u_div1__058_/Y u_dll_u_div1__097_/A VPWR VGND sg13cmos5l_inv_1
Xu_dll_u_control__1100_ u_dll_u_control__1189_/A u_dll_u_control__2283_/Q VPWR VGND
+ sg13cmos5l_inv_1
XFILLER_32_372 VPWR VGND sg13cmos5l_decap_8
Xu_dll_u_control__2080_ u_dll_u_control__2080_/Y u_dll_u_control__2105_/A VPWR VGND
+ sg13cmos5l_inv_1
Xu_dll_u_control__1933_ u_dll_u_control__1933_/Y u_dll_u_control__2095_/A VPWR VGND
+ sg13cmos5l_inv_1
XFILLER_10_15 VPWR VGND sg13cmos5l_fill_2
Xu_dll_u_control__1864_ u_dll_u_control__1864_/X u_dll_u_control__1864_/A u_dll_u_control__1864_/B
+ u_dll_u_control__1864_/C VPWR VGND sg13cmos5l_or3_1
Xu_dll_u_control__1795_ u_dll_u_control__2228_/D u_dll_u_control__2157_/Q u_dll_u_control__1797_/B
+ VPWR VGND sg13cmos5l_and2_1
Xu_dll_u_control__2278_ u_dll_u_control__2278_/Q u_dll_u_control__2279_/CLK u_dll_u_control__2278_/D
+ u_dll_u_control__1938_/Y VPWR VGND sg13cmos5l_dfrbpq_1
Xu_dll_u_control__1229_ u_dll_u_control__1229_/Y u_dll_u_control__1166_/Y u_dll_u_control__1247_/A
+ u_dll_u_control__1245_/S VPWR VGND sg13cmos5l_o21ai_1
Xu_dll_u_div0__076_ u_dll_u_div0__088_/A u_dll_u_div0__071_/Y u_dll_u_div0__074_/Y
+ u_dll_u_div0__075_/Y VPWR VGND sg13cmos5l_o21ai_1
XFILLER_33_147 VPWR VGND sg13cmos5l_fill_1
Xu_dll_u_control__1580_ u_dll_u_control__1580_/X u_dll_u_control__2134_/Q u_dll_u_control__2240_/Q
+ VPWR VGND sg13cmos5l_and2_1
Xu_dll_u_control__2132_ u_dll_u_control__2132_/Q u_dll_u_control__2316_/CLK u_dll_u_control__2132_/D
+ u_dll_u_control__1989_/Y VPWR VGND sg13cmos5l_dfrbpq_1
Xu_dll_u_control__2201_ u_dll_u_control__2201_/Q u_dll_u_control__2206_/CLK u_dll_u_control__2201_/D
+ u_dll_u_control__2058_/Y VPWR VGND sg13cmos5l_dfrbpq_1
XFILLER_32_191 VPWR VGND sg13cmos5l_fill_2
Xu_dll_u_control__2063_ u_dll_u_control__2063_/Y u_dll_u_control__2063_/A VPWR VGND
+ sg13cmos5l_inv_1
XFILLER_20_353 VPWR VGND sg13cmos5l_fill_1
XFILLER_20_364 VPWR VGND sg13cmos5l_decap_4
Xu_dll_u_control__1916_ u_dll_u_control__1916_/Y u_dll_u_control__1899_/B u_dll_u_control__1910_/A
+ u_dll_u_control__1909_/A VPWR VGND sg13cmos5l_o21ai_1
XFILLER_47_228 VPWR VGND sg13cmos5l_decap_8
XFILLER_46_11 VPWR VGND sg13cmos5l_fill_2
Xu_dll_u_control__1778_ u_dll_u_control__1778_/Y u_dll_u_control__1784_/A u_dll_u_control__1777_/Y
+ u_dll_u_control__1679_/A VPWR VGND sg13cmos5l_o21ai_1
Xu_dll_u_control__1847_ u_dll_u_control__1848_/C u_dll_u_control__1238_/A u_dll_u_control__1841_/D
+ u_dll_u_control__1859_/B VPWR VGND sg13cmos5l_a21oi_1
XFILLER_46_44 VPWR VGND sg13cmos5l_fill_1
XFILLER_7_16 VPWR VGND sg13cmos5l_fill_2
Xu_dll_u_ring_dstage\[8\].id_core_delaymux1_u_sel u_dll_u_ring_dstage\[8\].id_core_delaymux1_u_a0/B
+ u_dll_u_ring_dstage\[8\].id_core_delaymux1_u_a1/B VPWR VGND sg13cmos5l_inv_1
Xu_dll_u_ring_dstage\[11\].id_core_trim_reset_inv_u_inv u_dll_u_ring_dstage\[11\].id_core_trim_reset_inv_u_inv/Y
+ u_dll_u_ring_trim_reset_buffers\[3\].u_buffer_u_buf/X VPWR VGND sg13cmos5l_inv_2
XFILLER_11_397 VPWR VGND sg13cmos5l_decap_4
Xu_dll_u_ring_dstage\[1\].id_const0_u_lo u_dll_u_ring_dstage\[1\].id_const0_u_lo/L_LO
+ VPWR VGND sg13cmos5l_tielo
Xu_dll_u_div0__059_ u_dll_u_div0__062_/B u_dll_u_div0__106_/Q u_dll_u_div0__107_/Q
+ VPWR VGND sg13cmos5l_nor2b_1
Xu_dll__40_ u_dll__41_/D u_dll__35_/Y u_dll__40_/D u_dll__22_/X VPWR VGND sg13cmos5l_dfrbpq_1
Xclkbuf_5_29__f_u_dll\_controller_ref_clk u_dll_u_control__2145_/CLK clkbuf_4_14_0_u_dll\_controller_ref_clk/X
+ VPWR VGND sg13cmos5l_buf_8
Xu_dll_u_control__1701_ u_dll_u_control__1702_/B u_dll_u_control__2214_/Q u_dll_u_control__1701_/B
+ VPWR VGND sg13cmos5l_xnor2_1
Xu_dll_u_control__1632_ u_dll_u_control__1663_/B u_dll_u_control__1632_/A u_dll_u_control__1632_/B
+ VPWR VGND sg13cmos5l_xnor2_1
Xu_dll_u_control__1563_ u_dll_u_control__1565_/A u_dll_u_control__1719_/B u_dll_u_control__1567_/C
+ VPWR VGND sg13cmos5l_nor2_1
Xu_dll_u_div0_u_bypass_mux_u_a0 u_dll_u_div0_u_bypass_mux_u_a0/Y u_dll_u_div0_u_bypass_mux_u_a0/A
+ u_dll_u_div0_u_bypass_mux_u_a0/B VPWR VGND sg13cmos5l_nand2_2
XFILLER_29_228 VPWR VGND sg13cmos5l_fill_1
XFILLER_37_294 VPWR VGND sg13cmos5l_fill_2
Xu_dll_u_control__1494_ u_dll_u_control__1496_/B u_dll_u_control__2185_/Q u_dll_u_control__1506_/B
+ VPWR VGND sg13cmos5l_nor2_1
Xu_dll_u_control__2115_ u_dll_u_control__2115_/Y u_dll_u_control__2118_/A VPWR VGND
+ sg13cmos5l_inv_1
XFILLER_4_316 VPWR VGND sg13cmos5l_decap_8
Xu_dll_u_control__2046_ u_dll_u_control__2046_/Y u_dll_u_control__2056_/A VPWR VGND
+ sg13cmos5l_inv_1
XFILLER_35_209 VPWR VGND sg13cmos5l_fill_1
Xclkbuf_4_8__f_u_dll\_controller_ring_clk u_dll_u_control__2299_/CLK clkbuf_3_4_0_u_dll\_controller_ring_clk/X
+ VPWR VGND sg13cmos5l_buf_8
Xu_dll_u_ring_dstage\[3\].id_core_trim_sync\[1\].applied_u_ff u_dll_u_ring_dstage\[3\].id_core_long_gate_u_nand/B
+ u_dll_u_ring_dstage\[3\].id_core_delayinv1_u_inv/Y u_dll_u_ring_dstage\[3\].id_core_trim_sync\[1\].meta_u_ff/Q
+ u_dll_u_ring_dstage\[3\].id_core_trim_reset_inv_u_inv/Y VPWR VGND sg13cmos5l_dfrbpq_1
XFILLER_3_393 VPWR VGND sg13cmos5l_decap_8
XFILLER_19_250 VPWR VGND sg13cmos5l_fill_2
Xu_dll__23_ u_dll__23_/X u_dll__26_/A u_dll__26_/B VPWR VGND sg13cmos5l_and2_1
Xu_dll_u_control__1615_ u_dll_u_control__1615_/X u_dll_u_control__1878_/B u_dll_u_control__1469_/B
+ u_dll_u_control__1737_/A VPWR VGND sg13cmos5l_a21o_1
Xu_dll_u_control__1546_ u_dll_u_control__1546_/Y u_dll_u_control__1926_/A u_dll_u_control__1724_/B
+ VPWR VGND sg13cmos5l_nand2b_1
Xu_dll_u_control__1477_ u_dll_u_control__1478_/C u_dll_u_control__2163_/Q u_dll_u_control__1507_/B
+ VPWR VGND sg13cmos5l_nor2_1
Xclkbuf_4_8_0_u_dll\_controller_ref_clk clkbuf_4_8_0_u_dll\_controller_ref_clk/X clkbuf_4_9_0_u_dll\_controller_ref_clk/A
+ VPWR VGND sg13cmos5l_buf_8
XFILLER_43_12 VPWR VGND sg13cmos5l_fill_2
XFILLER_40_245 VPWR VGND sg13cmos5l_fill_1
Xu_dll_u_control__2029_ u_dll_u_control__2029_/Y u_dll_u_control__2124_/A VPWR VGND
+ sg13cmos5l_inv_1
Xu_dll_u_div1__091_ u_dll_u_div1__093_/B u_dll_u_div1__109_/Q u_dll_u_div1__103_/Q
+ VPWR VGND sg13cmos5l_xnor2_1
XFILLER_48_356 VPWR VGND sg13cmos5l_decap_8
Xu_dll_u_ring_dstage\[8\].id_core_reset_inv_u_inv u_dll_u_ring_dstage\[8\].id_core_reset_inv_u_inv/Y
+ u_dll_u_ring_dstage\[8\].id_const0_u_lo/L_LO VPWR VGND sg13cmos5l_inv_1
Xu_dll_u_control_fanout90 u_dll_u_control__2119_/A u_dll_u_control__2077_/A VPWR VGND
+ sg13cmos5l_buf_1
Xclkbuf_1_0_0_u_dll\_controller_ref_clk clkbuf_2_1_0_u_dll\_controller_ref_clk/A clkbuf_0_u_dll\_controller_ref_clk/X
+ VPWR VGND sg13cmos5l_buf_8
XFILLER_39_378 VPWR VGND sg13cmos5l_decap_4
Xu_dll_u_ring_reset_buffer_u_buf u_dll_u_ring_reset_buffer_u_buf/X u_dll_fanout80/X
+ VPWR VGND sg13cmos5l_buf_4
Xu_dll_u_control__1331_ u_dll_u_control__1332_/B u_dll_u_control__1923_/B u_dll_u_control__1334_/B
+ VPWR VGND sg13cmos5l_or2_1
Xu_dll_u_control__1400_ u_dll_u_control__1400_/Y u_dll_u_control__2186_/Q u_dll_u_control__1410_/B
+ VPWR VGND sg13cmos5l_nand2_1
Xu_dll_u_control__1193_ u_dll_u_control__1194_/B u_dll_u_control__2283_/Q u_dll_u_control__1189_/B
+ u_dll_u_control__2284_/Q VPWR VGND sg13cmos5l_a21o_1
XFILLER_22_212 VPWR VGND sg13cmos5l_decap_8
Xu_dll_u_control__1262_ u_dll_u_control__1263_/B u_dll_u_control__1687_/B u_dll_u_control__1262_/B
+ u_dll_u_control__2280_/D VPWR VGND sg13cmos5l_nand3_1
XFILLER_22_289 VPWR VGND sg13cmos5l_decap_8
XFILLER_38_89 VPWR VGND sg13cmos5l_fill_2
XFILLER_38_78 VPWR VGND sg13cmos5l_fill_1
Xu_dll_u_control__1529_ u_dll_u_control__1531_/B u_dll_u_control__2229_/Q u_dll_u_control__1529_/B
+ VPWR VGND sg13cmos5l_xnor2_1
Xu_dll_u_ring_dstage\[11\].id_core_delaymux1_u_a1 u_dll_u_ring_dstage\[11\].id_core_delaymux1_u_a1/Y
+ u_dll_u_ring_dstage\[11\].id_core_delaymux1_u_a1/A u_dll_u_ring_dstage\[11\].id_core_delaymux1_u_a1/B
+ VPWR VGND sg13cmos5l_nand2_2
XFILLER_9_238 VPWR VGND sg13cmos5l_fill_2
Xu_dll_u_ring_dstage\[6\].id_const0_u_lo u_dll_u_ring_dstage\[6\].id_const0_u_lo/L_LO
+ VPWR VGND sg13cmos5l_tielo
XFILLER_13_212 VPWR VGND sg13cmos5l_fill_2
Xu_dll_u_div1__074_ u_dll_u_div1__074_/Y u_dll_u_div1__105_/Q u_dll_u_div1__072_/Y
+ u_dll_u_div1__073_/Y VPWR VGND sg13cmos5l_o21ai_1
Xheichips26_multimode_dll_small_121 uo_out[7] VPWR VGND sg13cmos5l_tielo
Xheichips26_multimode_dll_small_110 uio_out[1] VPWR VGND sg13cmos5l_tielo
XFILLER_44_392 VPWR VGND sg13cmos5l_decap_8
Xu_dll_u_control__1880_ u_dll_u_control__2277_/D u_dll_u_control__1881_/B u_dll_u_control__1880_/B
+ u_dll_u_control__1880_/C VPWR VGND sg13cmos5l_nor3_1
XFILLER_5_60 VPWR VGND sg13cmos5l_fill_1
Xu_dll_u_control__1314_ u_dll_u_control__1716_/C u_dll_u_control__1741_/A u_dll_u_control__1741_/B
+ VPWR VGND sg13cmos5l_nor2_1
XFILLER_27_304 VPWR VGND sg13cmos5l_fill_2
Xu_dll_u_control__2294_ u_dll_u_control__2294_/Q u_dll_u_control__2300_/CLK u_dll_u_control__2294_/D
+ u_dll_u_control__1954_/Y VPWR VGND sg13cmos5l_dfrbpq_1
XFILLER_35_370 VPWR VGND sg13cmos5l_decap_8
Xu_dll_u_control__1176_ u_dll_u_control__1176_/Y u_dll_u_control__1189_/A u_dll_u_control__1241_/A
+ VPWR VGND sg13cmos5l_xnor2_1
Xu_dll_u_control__1245_ u_dll_u_control__1245_/X u_dll_u_control__1187_/Y u_dll_u_control__1242_/X
+ u_dll_u_control__1245_/S VPWR VGND sg13cmos5l_mux2_1
Xu_dll_u_ring_dstage\[7\].id_core_delaybuf1_u_buf u_dll_u_ring_dstage\[7\].id_core_delayinv1_u_inv/A
+ u_dll_u_ring_dstage\[7\].id_core_delaymux1_u_a1/A VPWR VGND sg13cmos5l_buf_1
XFILLER_10_259 VPWR VGND sg13cmos5l_fill_2
Xu_dll_u_div0__092_ u_dll_u_div0__093_/C u_dll_u_div0__110_/Q u_dll_u_div0__104_/Q
+ VPWR VGND sg13cmos5l_xnor2_1
XFILLER_45_101 VPWR VGND sg13cmos5l_fill_1
XFILLER_5_263 VPWR VGND sg13cmos5l_decap_8
Xu_dll_u_div1__057_ u_dll_u_div1__097_/A u_dll_u_div1__109_/Q u_dll_u_div1__108_/Q
+ u_dll_u_div1__110_/Q u_dll_u_div1__060_/D VPWR VGND sg13cmos5l_nor4_1
XFILLER_24_329 VPWR VGND sg13cmos5l_fill_1
Xu_dll_u_control__1932_ u_dll_u_control__1932_/Y u_dll_u_control__2099_/A VPWR VGND
+ sg13cmos5l_inv_1
XFILLER_10_27 VPWR VGND sg13cmos5l_fill_1
Xu_dll_u_control__1863_ u_dll_u_control__1863_/X u_dll_u_control__1863_/A u_dll_u_control__1863_/B
+ VPWR VGND sg13cmos5l_or2_1
Xu_dll_u_control__1794_ u_dll_u_control__2227_/D u_dll_u_control__2156_/Q u_dll_u_control__1797_/B
+ VPWR VGND sg13cmos5l_and2_1
Xu_dll_u_control__2277_ u_dll_u_control__2277_/Q u_dll_u_control__2277_/CLK u_dll_u_control__2277_/D
+ u_dll_u_control__1937_/Y VPWR VGND sg13cmos5l_dfrbpq_1
XFILLER_35_79 VPWR VGND sg13cmos5l_fill_2
XFILLER_35_13 VPWR VGND sg13cmos5l_decap_8
Xu_dll_u_control__1159_ u_dll_u_control__1161_/B u_dll_u_control__1163_/B u_dll_u_control__1162_/C
+ u_dll_u_control__1189_/A VPWR VGND sg13cmos5l_a21oi_1
Xu_dll_u_control__1228_ u_dll_u_control__1228_/Y u_dll_u_control__1228_/A u_dll_u_control__1228_/B
+ VPWR VGND sg13cmos5l_nor2_1
Xu_dll_u_div0__075_ u_dll_u_div0__075_/Y u_dll_u_div0__105_/Q u_dll_u_div0__072_/Y
+ u_dll_u_div0__097_/A VPWR VGND sg13cmos5l_a21oi_1
Xu_dll_u_ring_dstage\[8\].id_core_short_decode_u_and u_dll_u_ring_dstage\[8\].id_core_short_gate_u_nand/B
+ u_dll_u_ring_dstage\[8\].id_core_delaymux1_u_a1/B u_dll_u_ring_dstage\[8\].id_core_short_decode_u_and/B
+ VPWR VGND sg13cmos5l_and2_2
Xu_dll_u_div1_u_output_inv1_u_inv u_dll_u_div1_u_clkbuf_out_u_buf/A u_dll_u_div1_u_output_inv1_u_inv/A
+ VPWR VGND sg13cmos5l_inv_2
Xu_dll_u_div1__109_ u_dll_u_div1__109_/Q u_dll_u_div1__110_/CLK u_dll_u_div1__114_/Q
+ u_dll_u_div1_fanout60/X VPWR VGND sg13cmos5l_dfrbpq_1
Xu_dll_u_control__2200_ u_dll_u_control__2200_/Q u_dll_u_control__2206_/CLK u_dll_u_control__2200_/D
+ u_dll_u_control__2057_/Y VPWR VGND sg13cmos5l_dfrbpq_1
Xu_dll_u_control__2131_ u_dll_u_control__2131_/Q u_dll_u_control__2235_/CLK u_dll_u_control__2131_/D
+ u_dll_u_control__1988_/Y VPWR VGND sg13cmos5l_dfrbpq_1
Xu_dll_u_control__2062_ u_dll_u_control__2062_/Y u_dll_u_control__2064_/A VPWR VGND
+ sg13cmos5l_inv_1
Xu_dll_u_control__1846_ u_dll_u_control__1848_/B u_dll_u_control__1846_/A u_dll_u_control__1846_/B
+ u_dll_u_control__1849_/B u_dll_u_control__1846_/D VPWR VGND sg13cmos5l_nand4_1
Xu_dll_u_control__1915_ u_dll_u_control__2303_/D u_dll_u_control__2308_/Q u_dll_u_control__1905_/B
+ u_dll_u_control__1914_/Y VPWR VGND sg13cmos5l_a21oi_1
XFILLER_21_48 VPWR VGND sg13cmos5l_decap_4
Xu_dll_u_control__1777_ u_dll_u_control__1777_/Y u_dll_u_control__1776_/A u_dll_u_control__1776_/B
+ u_dll_u_control__1789_/B VPWR VGND sg13cmos5l_a21oi_1
Xu_dll_u_control_fanout1 u_dll_u_control__1673_/C u_dll_u_control__1663_/C VPWR VGND
+ sg13cmos5l_buf_1
Xu_dll_u_div0__058_ u_dll_u_div0__058_/Y u_dll_u_div0__097_/A VPWR VGND sg13cmos5l_inv_1
XFILLER_11_354 VPWR VGND sg13cmos5l_fill_1
Xu_dll_u_control__1700_ u_dll_u_control__2213_/D u_dll_u_control__1701_/B u_dll_u_control__1706_/A
+ u_dll_u_control__1700_/C VPWR VGND sg13cmos5l_nor3_1
Xu_dll_u_control__1631_ u_dll_u_control__1661_/B u_dll_u_control__1631_/A u_dll_u_control__1631_/B
+ VPWR VGND sg13cmos5l_xnor2_1
Xu_dll_u_control__1562_ u_dll_u_control__1567_/C u_dll_u_control__1741_/B u_dll_u_control__1562_/B
+ VPWR VGND sg13cmos5l_nor2_1
Xu_dll_u_div0_u_bypass_mux_u_a1 u_dll_u_div0_u_bypass_mux_u_a1/Y u_dll_u_div0_buffer_u_buf/X
+ u_dll_u_div0__061_/Y VPWR VGND sg13cmos5l_nand2_2
Xu_dll_u_control__1493_ u_dll_u_control__2158_/D u_dll_u_control__1508_/A u_dll_u_control__1493_/B
+ u_dll_u_control__1493_/C VPWR VGND sg13cmos5l_nor3_1
Xu_dll_u_control__2114_ u_dll_u_control__2114_/Y u_dll_u_control__2127_/A VPWR VGND
+ sg13cmos5l_inv_1
Xu_dll_u_control__2045_ u_dll_u_control__2045_/Y u_dll_u_control__2056_/A VPWR VGND
+ sg13cmos5l_inv_1
XFILLER_25_402 VPWR VGND sg13cmos5l_fill_2
Xu_dll_u_control__1829_ u_dll_u_control__1829_/X u_dll_u_control__1829_/A u_dll_u_control__1841_/C
+ u_dll_u_control__1834_/C VPWR VGND sg13cmos5l_and3_1
XFILLER_16_402 VPWR VGND sg13cmos5l_fill_2
XFILLER_14_4 VPWR VGND sg13cmos5l_fill_2
Xu_dll_u_ring_dstage\[9\].id_core_delaymux1_u_a0 u_dll_u_ring_dstage\[9\].id_core_delaymux1_u_a0/Y
+ u_dll_u_ring_dstage\[9\].id_core_delaymux1_u_a0/A u_dll_u_ring_dstage\[9\].id_core_delaymux1_u_a0/B
+ VPWR VGND sg13cmos5l_nand2_2
Xu_dll__22_ u_dll__22_/X u_dll__26_/A u_dll__26_/B VPWR VGND sg13cmos5l_and2_1
Xu_dll_u_control__1614_ u_dll_u_control__1737_/A u_dll_u_control__1741_/B u_dll_u_control__1713_/A
+ VPWR VGND sg13cmos5l_nor2_1
Xu_dll_u_control__1545_ u_dll_u_control__1545_/Y u_dll_u_control__1545_/A u_dll_u_control__1545_/B
+ VPWR VGND sg13cmos5l_nor2_1
Xu_dll_u_control__1476_ u_dll_u_control__1478_/B u_dll_u_control__2191_/Q u_dll_u_control__1485_/B
+ VPWR VGND sg13cmos5l_nor2_1
XFILLER_40_257 VPWR VGND sg13cmos5l_fill_2
Xu_dll_u_control__2028_ u_dll_u_control__2028_/Y u_dll_u_control__2124_/A VPWR VGND
+ sg13cmos5l_inv_1
Xu_dll_u_ring_dstage\[3\].id_core_slow_isolation_u_buf u_dll_u_ring_dstage\[3\].id_core_delaymux1_u_a1/A
+ u_dll_u_ring_dstage\[2\].id_core_reset_gate_u_aoi/Y VPWR VGND sg13cmos5l_buf_2
Xu_dll_u_div1__090_ u_dll_u_div1__093_/A u_dll_u_div1__101_/Q u_dll_u_div1__107_/Q
+ VPWR VGND sg13cmos5l_xor2_1
XFILLER_0_386 VPWR VGND sg13cmos5l_decap_8
XFILLER_31_224 VPWR VGND sg13cmos5l_decap_4
XFILLER_31_213 VPWR VGND sg13cmos5l_fill_2
Xu_dll_u_control_fanout91 u_dll_u_control__2077_/A u_dll_u_control__2002_/A VPWR VGND
+ sg13cmos5l_buf_1
XFILLER_39_346 VPWR VGND sg13cmos5l_decap_8
Xu_dll_u_control__1261_ u_dll_u_control__2280_/D u_dll_u_control__1876_/A u_dll_u_control__1844_/B
+ VPWR VGND sg13cmos5l_nor2_1
Xu_dll_u_control__1330_ u_dll_u_control__1334_/B u_dll_u_control__2207_/Q u_dll_u_control__2204_/Q
+ u_dll_u_control__2203_/Q u_dll_u_control__2202_/Q VPWR VGND sg13cmos5l_nand4_1
Xu_dll_u_ring_dstage\[10\].id_core_delaymux1_u_merge u_dll_u_ring_dstage\[10\].id_core_long_gate_u_nand/A
+ u_dll_u_ring_dstage\[10\].id_core_delaymux1_u_a0/Y u_dll_u_ring_dstage\[10\].id_core_delaymux1_u_a1/Y
+ VPWR VGND sg13cmos5l_nand2_2
Xu_dll_u_control__1192_ u_dll_u_control__1192_/Y u_dll_u_control__1184_/Y u_dll_u_control__1188_/Y
+ u_dll_u_control__1207_/A u_dll_u_control__1140_/X u_dll_u_control__1191_/Y VPWR
+ VGND sg13cmos5l_a221oi_1
XFILLER_22_268 VPWR VGND sg13cmos5l_decap_8
Xclkbuf_4_0__f_u_dll\_controller_ring_clk u_dll_u_control__2319_/CLK clkbuf_3_0_0_u_dll\_controller_ring_clk/X
+ VPWR VGND sg13cmos5l_buf_8
Xu_dll_u_control__1528_ u_dll_u_control__1531_/A u_dll_u_control__2231_/Q u_dll_u_control__1528_/B
+ VPWR VGND sg13cmos5l_xnor2_1
Xu_dll_u_control__1459_ u_dll_u_control__1460_/B u_dll_u_control__2168_/Q u_dll_u_control__1462_/A
+ u_dll_u_control__1420_/B VPWR VGND sg13cmos5l_o21ai_1
Xu_dll_u_ring_dstage\[11\].id_core_trim_sync\[1\].applied_u_ff u_dll_u_ring_dstage\[11\].id_core_long_gate_u_nand/B
+ u_dll_u_ring_dstage\[11\].id_core_delayinv1_u_inv/Y u_dll_u_ring_dstage\[11\].id_core_trim_sync\[1\].meta_u_ff/Q
+ u_dll_u_ring_dstage\[11\].id_core_trim_reset_inv_u_inv/Y VPWR VGND sg13cmos5l_dfrbpq_1
Xu_dll_u_div1__073_ u_dll_u_div1__073_/Y u_dll_u_div1__072_/B u_dll_u_div1__069_/C
+ u_dll_u_div1__085_/A VPWR VGND sg13cmos5l_o21ai_1
XFILLER_36_338 VPWR VGND sg13cmos5l_decap_8
Xheichips26_multimode_dll_small_111 uio_out[2] VPWR VGND sg13cmos5l_tielo
XFILLER_44_371 VPWR VGND sg13cmos5l_decap_8
XFILLER_39_132 VPWR VGND sg13cmos5l_fill_1
Xu_dll_u_control__1244_ u_dll_u_control__1684_/B u_dll_u_control__1246_/B u_dll_u_control__1242_/X
+ u_dll_u_control__1243_/Y VPWR VGND sg13cmos5l_o21ai_1
Xu_dll_u_control__1313_ u_dll_u_control__1706_/A u_dll_u_control__1814_/A u_dll_u_control__1707_/C
+ VPWR VGND sg13cmos5l_nand2_1
XFILLER_27_349 VPWR VGND sg13cmos5l_fill_2
Xu_dll_u_control__2293_ u_dll_u_control__2293_/Q u_dll_u_control__2299_/CLK u_dll_u_control__2293_/D
+ u_dll_u_control__1953_/Y VPWR VGND sg13cmos5l_dfrbpq_1
Xu_dll_u_div0__091_ u_dll_u_div0__093_/B u_dll_u_div0__109_/Q u_dll_u_div0__103_/Q
+ VPWR VGND sg13cmos5l_xnor2_1
Xu_dll_u_control__1175_ u_dll_u_control__1241_/A u_dll_u_control__2282_/Q u_dll_u_control__2281_/Q
+ u_dll_u_control__1183_/A VPWR VGND sg13cmos5l_nand3_1
XFILLER_49_67 VPWR VGND sg13cmos5l_decap_8
XFILLER_1_19 VPWR VGND sg13cmos5l_fill_1
XFILLER_41_385 VPWR VGND sg13cmos5l_fill_2
XFILLER_41_352 VPWR VGND sg13cmos5l_fill_1
XFILLER_5_242 VPWR VGND sg13cmos5l_decap_8
XFILLER_46_7 VPWR VGND sg13cmos5l_decap_4
Xu_dll_u_div1__056_ u_dll_u_div1__056_/Y u_dll_u_div1__056_/A VPWR VGND sg13cmos5l_inv_1
XFILLER_17_382 VPWR VGND sg13cmos5l_fill_1
Xu_dll_u_control__1931_ u_dll_u_control__2317_/D u_dll_u_control__2316_/Q VPWR VGND
+ sg13cmos5l_buf_1
Xu_dll_u_control__1862_ u_dll_u_control__2247_/D u_dll_u_control__1846_/A u_dll_u_control__1846_/D
+ u_dll_u_control__1287_/Y u_dll_u_control__1238_/A u_dll_u_control__1860_/A VPWR
+ VGND sg13cmos5l_a221oi_1
Xu_dll_u_ring_dstage\[7\].id_core_trim_sync\[0\].applied_u_ff u_dll_u_ring_dstage\[7\].id_core_delaymux1_u_a1/B
+ u_dll_u_ring_dstage\[7\].id_core_delayinv1_u_inv/Y u_dll_u_ring_dstage\[7\].id_core_trim_sync\[0\].meta_u_ff/Q
+ u_dll_u_ring_dstage\[7\].id_core_trim_reset_inv_u_inv/Y VPWR VGND sg13cmos5l_dfrbpq_1
Xu_dll_u_control__1793_ u_dll_u_control__2226_/D u_dll_u_control__2155_/Q u_dll_u_control__1814_/A
+ VPWR VGND sg13cmos5l_and2_1
XFILLER_19_48 VPWR VGND sg13cmos5l_fill_2
Xu_dll_u_control__2276_ u_dll_u_control__2276_/Q u_dll_u_control__2277_/CLK u_dll_u_control__2276_/D
+ u_dll_u_control__1936_/Y VPWR VGND sg13cmos5l_dfrbpq_1
XFILLER_42_105 VPWR VGND sg13cmos5l_fill_1
Xu_dll_u_control__1227_ u_dll_u_control__1228_/B u_dll_u_control__1227_/A u_dll_u_control__1227_/B
+ VPWR VGND sg13cmos5l_xnor2_1
XFILLER_15_319 VPWR VGND sg13cmos5l_decap_4
Xu_dll_u_control__1089_ u_dll_u_control__1571_/A u_dll_u_control__2140_/Q VPWR VGND
+ sg13cmos5l_inv_1
Xu_dll_u_control__1158_ u_dll_u_control__1162_/C u_dll_u_control__1147_/B u_dll_u_control__1147_/C
+ u_dll_u_control__1147_/D VPWR VGND sg13cmos5l_a21o_1
Xu_dll_u_div0__074_ u_dll_u_div0__074_/Y u_dll_u_div0__105_/Q u_dll_u_div0__072_/Y
+ u_dll_u_div0__073_/Y VPWR VGND sg13cmos5l_o21ai_1
XFILLER_2_245 VPWR VGND sg13cmos5l_decap_4
XFILLER_44_4 VPWR VGND sg13cmos5l_fill_1
XFILLER_49_293 VPWR VGND sg13cmos5l_decap_8
Xu_dll_u_div1__108_ u_dll_u_div1__108_/Q u_dll_u_div1__110_/CLK u_dll_u_div1__113_/Q
+ u_dll_u_div1_fanout60/X VPWR VGND sg13cmos5l_dfrbpq_1
Xu_dll_u_control__2061_ u_dll_u_control__2061_/Y u_dll_u_control__2063_/A VPWR VGND
+ sg13cmos5l_inv_1
Xu_dll_u_control__2130_ u_dll_u_control__2130_/Q u_dll_u_control__2312_/CLK u_dll_u_control__2130_/D
+ u_dll_u_control__1987_/Y VPWR VGND sg13cmos5l_dfrbpq_1
XFILLER_32_193 VPWR VGND sg13cmos5l_fill_1
XFILLER_20_399 VPWR VGND sg13cmos5l_decap_4
Xu_dll_u_control__1776_ u_dll_u_control__1784_/B u_dll_u_control__1776_/A u_dll_u_control__1776_/B
+ VPWR VGND sg13cmos5l_nand2_1
Xu_dll_u_control__1914_ u_dll_u_control__1914_/Y u_dll_u_control__2308_/Q u_dll_u_control__1905_/B
+ u_dll_u_control__1909_/A VPWR VGND sg13cmos5l_o21ai_1
Xu_dll_u_control__1845_ u_dll_u_control__2254_/D u_dll_u_control__1858_/B u_dll_u_control__1855_/B
+ u_dll_u_control__1845_/C VPWR VGND sg13cmos5l_nor3_1
XFILLER_7_18 VPWR VGND sg13cmos5l_fill_1
XFILLER_11_333 VPWR VGND sg13cmos5l_fill_1
Xu_dll_u_control__2259_ u_dll_u_control__2259_/Q u_dll_u_control__2271_/CLK u_dll_u_control__2259_/D
+ u_dll_u_control__2116_/Y VPWR VGND sg13cmos5l_dfrbpq_1
Xu_dll_u_div0__057_ u_dll_u_div0__097_/A u_dll_u_div0__109_/Q u_dll_u_div0__108_/Q
+ u_dll_u_div0__110_/Q u_dll_u_div0__060_/D VPWR VGND sg13cmos5l_nor4_1
Xu_dll_u_control_fanout2 u_dll_u_control__1834_/B u_dll_u_control__1245_/X VPWR VGND
+ sg13cmos5l_buf_1
XFILLER_2_0 VPWR VGND sg13cmos5l_fill_2
Xclkbuf_3_0_0_u_dll\_controller_ring_clk clkbuf_3_0_0_u_dll\_controller_ring_clk/X
+ clkbuf_3_3_0_u_dll\_controller_ring_clk/A VPWR VGND sg13cmos5l_buf_8
XFILLER_38_219 VPWR VGND sg13cmos5l_fill_1
Xu_dll_u_ring_dstage\[2\].id_core_reset_gate_u_aoi u_dll_u_ring_dstage\[2\].id_core_reset_gate_u_aoi/Y
+ u_dll_u_ring_dstage\[1\].id_core_reset_gate_u_aoi/Y u_dll_u_ring_dstage\[2\].id_core_reset_gate_u_aoi/A2
+ u_dll_u_ring_dstage\[2\].id_core_reset_gate_u_aoi/B1 VPWR VGND sg13cmos5l_a21oi_2
XFILLER_34_403 VPWR VGND sg13cmos5l_fill_1
Xu_dll_u_control__1630_ u_dll_u_control__1659_/B u_dll_u_control__1630_/A u_dll_u_control__1630_/B
+ VPWR VGND sg13cmos5l_xnor2_1
XFILLER_35_0 VPWR VGND sg13cmos5l_decap_4
XFILLER_6_381 VPWR VGND sg13cmos5l_fill_1
Xu_dll_u_control__1561_ u_dll_u_control__1561_/Y u_dll_u_control__1562_/B VPWR VGND
+ sg13cmos5l_inv_1
XFILLER_16_16 VPWR VGND sg13cmos5l_fill_2
Xu_dll_u_control__1492_ u_dll_u_control__1493_/C u_dll_u_control__2158_/Q u_dll_u_control__1501_/B
+ VPWR VGND sg13cmos5l_nor2_1
Xu_dll_u_div1_u_clkbuf_config_u_buf u_dll_u_div1__110_/CLK u_dll_u_div1_buffer_u_buf/X
+ VPWR VGND sg13cmos5l_buf_4
Xu_dll_u_control__2113_ u_dll_u_control__2113_/Y u_dll_u_control__2124_/A VPWR VGND
+ sg13cmos5l_inv_1
Xu_dll_u_control__2044_ u_dll_u_control__2044_/Y u_dll_u_control__2056_/A VPWR VGND
+ sg13cmos5l_inv_1
XFILLER_20_141 VPWR VGND sg13cmos5l_fill_2
XFILLER_32_59 VPWR VGND sg13cmos5l_fill_1
Xu_dll_u_control__1759_ u_dll_u_control__1764_/A u_dll_u_control__1752_/A u_dll_u_control__1757_/Y
+ u_dll_u_control__1758_/Y VPWR VGND sg13cmos5l_o21ai_1
Xu_dll_u_control__1828_ u_dll_u_control__1828_/Y u_dll_u_control__1827_/B u_dll_u_control__1851_/C
+ VPWR VGND sg13cmos5l_nand2b_1
XFILLER_43_266 VPWR VGND sg13cmos5l_fill_2
Xu_dll_u_ring_dstage\[5\].id_core_secondary_inv_u_inv u_dll_u_ring_dstage\[5\].id_core_short_decode_u_and/B
+ u_dll_u_ring_dstage\[5\].id_core_long_gate_u_nand/B VPWR VGND sg13cmos5l_inv_1
Xu_dll_u_div1_u_output_inv0_u_inv u_dll_u_div1_u_output_inv1_u_inv/A u_dll_u_div1_u_run_gate_u_and/X
+ VPWR VGND sg13cmos5l_inv_2
Xu_dll_u_div0__109_ u_dll_u_div0__109_/Q u_dll_u_div0__110_/CLK u_dll_u_div0__114_/Q
+ u_dll_u_div0_fanout59/X VPWR VGND sg13cmos5l_dfrbpq_1
Xu_dll_u_ring_dstage\[9\].id_core_delaymux1_u_a1 u_dll_u_ring_dstage\[9\].id_core_delaymux1_u_a1/Y
+ u_dll_u_ring_dstage\[9\].id_core_delaymux1_u_a1/A u_dll_u_ring_dstage\[9\].id_core_delaymux1_u_a1/B
+ VPWR VGND sg13cmos5l_nand2_2
Xu_dll__21_ uo_out[2] u_dll__26_/A u_dll__26_/B u_dll__21_/C VPWR VGND sg13cmos5l_and3_1
Xu_dll_u_control__1613_ u_dll_u_control__1713_/A u_dll_u_control__2223_/Q u_dll_u_control__1718_/A
+ VPWR VGND sg13cmos5l_and2_1
Xu_dll_u_control__1544_ u_dll_u_control__1545_/B u_dll_u_control__1537_/Y u_dll_u_control__1728_/A
+ u_dll_u_control__1542_/Y VPWR VGND sg13cmos5l_o21ai_1
Xu_dll_u_control__1475_ u_dll_u_control__2164_/D u_dll_u_control__1487_/A u_dll_u_control__1475_/B
+ u_dll_u_control__1475_/C VPWR VGND sg13cmos5l_nor3_1
XFILLER_27_37 VPWR VGND sg13cmos5l_decap_4
XFILLER_27_48 VPWR VGND sg13cmos5l_fill_2
XFILLER_27_59 VPWR VGND sg13cmos5l_decap_8
Xu_dll_u_control__2027_ u_dll_u_control__2027_/Y u_dll_u_control__2124_/A VPWR VGND
+ sg13cmos5l_inv_1
XFILLER_0_365 VPWR VGND sg13cmos5l_decap_8
XFILLER_16_266 VPWR VGND sg13cmos5l_fill_1
Xu_dll_u_ring_dstage\[10\].id_core_merge_gate_u_nand u_dll_u_ring_dstage\[10\].id_core_reset_gate_u_aoi/B1
+ u_dll_u_ring_dstage\[10\].id_core_short_gate_u_nand/Y u_dll_u_ring_dstage\[10\].id_core_long_gate_u_nand/Y
+ u_dll_u_ring_dstage\[10\].id_core_reset_inv_u_inv/Y VPWR VGND sg13cmos5l_nand3_1
Xu_dll_u_ring_dstage\[1\].id_core_delaymux1_u_sel u_dll_u_ring_dstage\[1\].id_core_delaymux1_u_a0/B
+ u_dll_u_ring_dstage\[1\].id_core_delaymux1_u_a1/B VPWR VGND sg13cmos5l_inv_1
Xu_dll_u_startup_buffer_u_buf u_dll__36_/A u_dll_u_div1_buffer_u_buf/A VPWR VGND sg13cmos5l_buf_2
Xu_dll_u_control_fanout92 u_dll_u_control__2102_/A u_dll_u_control__1999_/A VPWR VGND
+ sg13cmos5l_buf_1
Xu_dll_u_control_fanout70 u_dll_u_control__2056_/A u_dll_u_control__2048_/A VPWR VGND
+ sg13cmos5l_buf_1
Xu_dll_u_control_fanout81 u_dll_u_control__2118_/A u_dll_fanout82/X VPWR VGND sg13cmos5l_buf_1
XFILLER_47_391 VPWR VGND sg13cmos5l_decap_8
Xu_dll_u_control__1260_ u_dll_u_control__1844_/B u_dll_u_control__2280_/Q u_dll_u_control__1143_/Y
+ u_dll_u_control__1260_/S VPWR VGND sg13cmos5l_mux2_1
Xu_dll_u_control__1191_ u_dll_u_control__1191_/Y u_dll_u_control__1191_/A u_dll_u_control__1243_/A
+ VPWR VGND sg13cmos5l_nor2_1
XFILLER_22_247 VPWR VGND sg13cmos5l_decap_8
Xclkbuf_5_3__f_u_dll\_controller_ref_clk u_dll_u_control__2309_/CLK clkbuf_4_1_0_u_dll\_controller_ref_clk/X
+ VPWR VGND sg13cmos5l_buf_8
Xu_dll_u_control__1527_ u_dll_u_control__1746_/A u_dll_u_control__1523_/B u_dll_u_control__1522_/X
+ u_dll_u_control__1525_/Y u_dll_u_control__1526_/X u_dll_u_control__1523_/Y VPWR
+ VGND sg13cmos5l_a221oi_1
Xu_dll_u_control__1458_ u_dll_u_control__2169_/D u_dll_u_control__1458_/A u_dll_u_control__1458_/B
+ u_dll_u_control__1458_/C VPWR VGND sg13cmos5l_nor3_1
Xu_dll_u_control__1389_ u_dll_u_control__2192_/D u_dll_u_control__1337_/A u_dll_u_control__1397_/A2
+ u_dll_u_control__1388_/Y VPWR VGND sg13cmos5l_o21ai_1
Xu_dll_u_div1__072_ u_dll_u_div1__072_/Y u_dll_u_div1__110_/Q u_dll_u_div1__072_/B
+ VPWR VGND sg13cmos5l_xnor2_1
XFILLER_36_328 VPWR VGND sg13cmos5l_fill_1
Xheichips26_multimode_dll_small_112 uio_out[3] VPWR VGND sg13cmos5l_tielo
Xheichips26_multimode_dll_small_101 uio_oe[0] VPWR VGND sg13cmos5l_tielo
XFILLER_27_317 VPWR VGND sg13cmos5l_fill_1
XFILLER_27_306 VPWR VGND sg13cmos5l_fill_1
Xu_dll_u_control__1174_ u_dll_u_control__1247_/A u_dll_u_control__1169_/Y u_dll_u_control__1172_/Y
+ u_dll_u_control__1149_/X VPWR VGND sg13cmos5l_a21o_1
Xu_dll_u_control__1243_ u_dll_u_control__1243_/Y u_dll_u_control__1243_/A u_dll_u_control__1246_/B
+ VPWR VGND sg13cmos5l_nand2_1
Xu_dll_u_control__1312_ u_dll_u_control__1707_/C u_dll_u_control__1469_/B VPWR VGND
+ sg13cmos5l_inv_1
XFILLER_27_339 VPWR VGND sg13cmos5l_fill_2
Xu_dll_u_control__2292_ u_dll_u_control__2292_/Q u_dll_u_control__2300_/CLK u_dll_u_control__2292_/D
+ u_dll_u_control__1952_/Y VPWR VGND sg13cmos5l_dfrbpq_1
Xu_dll_u_div0__090_ u_dll_u_div0__093_/A u_dll_u_div0__101_/Q u_dll_u_div0__107_/Q
+ VPWR VGND sg13cmos5l_xor2_1
XFILLER_10_228 VPWR VGND sg13cmos5l_decap_4
XFILLER_49_13 VPWR VGND sg13cmos5l_fill_2
XFILLER_41_364 VPWR VGND sg13cmos5l_fill_1
Xu_dll_u_ring_dstage\[7\].id_core_delayint0_u_inv u_dll_u_ring_dstage\[7\].id_core_delaymux1_u_a0/A
+ u_dll_u_ring_dstage\[7\].id_core_delayinv1_u_inv/Y VPWR VGND sg13cmos5l_inv_1
Xu_dll_u_div1__055_ u_dll_u_div1__060_/D u_dll_u_div1__107_/Q VPWR VGND sg13cmos5l_inv_1
Xu_dll_u_ring_dstage\[2\].id_core_trim_sync\[0\].applied_u_ff u_dll_u_ring_dstage\[2\].id_core_delaymux1_u_a1/B
+ u_dll_u_ring_dstage\[2\].id_core_delayinv1_u_inv/Y u_dll_u_ring_dstage\[2\].id_core_trim_sync\[0\].meta_u_ff/Q
+ u_dll_u_ring_dstage\[2\].id_core_trim_reset_inv_u_inv/Y VPWR VGND sg13cmos5l_dfrbpq_1
Xu_dll_u_ring_dstage\[1\].id_core_reset_inv_u_inv u_dll_u_ring_dstage\[1\].id_core_reset_inv_u_inv/Y
+ u_dll_u_ring_dstage\[1\].id_const0_u_lo/L_LO VPWR VGND sg13cmos5l_inv_1
Xu_dll_u_control__1930_ u_dll_u_control__2319_/D u_dll_u_control__2318_/Q VPWR VGND
+ sg13cmos5l_buf_1
Xu_dll_u_control__1792_ u_dll_u_control__2225_/D u_dll_u_control__2154_/Q u_dll_u_control__1797_/B
+ VPWR VGND sg13cmos5l_and2_1
Xu_dll_u_control__1861_ u_dll_u_control__2248_/D u_dll_u_control__1829_/A u_dll_u_control__1859_/Y
+ u_dll_u_control__1860_/X u_dll_u_control__1285_/A VPWR VGND sg13cmos5l_a22oi_1
Xu_dll_u_control__2275_ u_dll_u_control__2275_/Q u_dll_u_control__2275_/CLK u_dll_u_control__2275_/D
+ u_dll_u_control__1935_/Y VPWR VGND sg13cmos5l_dfrbpq_1
Xu_dll_u_control__1157_ u_dll_u_control__1161_/A u_dll_u_control__2282_/Q u_dll_u_control__1160_/B
+ u_dll_u_control__1156_/Y u_dll_u_control__1143_/Y u_dll_u_control__1154_/Y VPWR
+ VGND sg13cmos5l_a221oi_1
XFILLER_35_191 VPWR VGND sg13cmos5l_decap_8
XFILLER_35_180 VPWR VGND sg13cmos5l_fill_2
Xu_dll_u_control__1226_ u_dll_u_control__1880_/B u_dll_u_control__1814_/A u_dll_u_control__1226_/B
+ VPWR VGND sg13cmos5l_nand2_1
XFILLER_15_309 VPWR VGND sg13cmos5l_fill_1
Xu_dll_u_control__1088_ u_dll_u_control__1131_/A u_dll_u_control__2141_/Q VPWR VGND
+ sg13cmos5l_inv_1
Xu_dll_u_div0__073_ u_dll_u_div0__073_/Y u_dll_u_div0__072_/B u_dll_u_div0__069_/C
+ u_dll_u_div0__085_/A VPWR VGND sg13cmos5l_o21ai_1
XFILLER_4_4 VPWR VGND sg13cmos5l_fill_1
XFILLER_14_375 VPWR VGND sg13cmos5l_fill_2
Xclkbuf_5_14__f_u_dll\_controller_ref_clk u_dll_u_control__2316_/CLK clkbuf_4_7_0_u_dll\_controller_ref_clk/X
+ VPWR VGND sg13cmos5l_buf_8
XFILLER_49_272 VPWR VGND sg13cmos5l_fill_1
Xu_dll_u_div1__107_ u_dll_u_div1__107_/Q u_dll_u_div1__110_/CLK u_dll_u_div1__107_/D
+ u_dll_u_div1_fanout60/X VPWR VGND sg13cmos5l_dfrbpq_1
XFILLER_32_183 VPWR VGND sg13cmos5l_fill_2
Xu_dll_u_control__2060_ u_dll_u_control__2060_/Y u_dll_u_control__2060_/A VPWR VGND
+ sg13cmos5l_inv_1
Xu_dll_u_control__1913_ u_dll_u_control__2302_/D u_dll_u_control__1913_/A u_dll_u_control__2307_/Q
+ VPWR VGND sg13cmos5l_nor2_1
Xu_dll_u_control__1775_ u_dll_u_control__1784_/A u_dll_u_control__1772_/Y u_dll_u_control__1773_/Y
+ u_dll_u_control__1774_/Y VPWR VGND sg13cmos5l_a21oi_1
Xu_dll_u_control__1844_ u_dll_u_control__1845_/C u_dll_u_control__1859_/B u_dll_u_control__1844_/B
+ u_dll_u_control__1844_/C VPWR VGND sg13cmos5l_and3_1
XFILLER_15_117 VPWR VGND sg13cmos5l_fill_1
Xu_dll_u_control__1209_ u_dll_u_control__1834_/A u_dll_u_control__1205_/Y u_dll_u_control__1206_/Y
+ u_dll_u_control__1207_/Y VPWR VGND sg13cmos5l_a21oi_1
Xu_dll_u_control_fanout3 u_dll_u_control__1851_/C u_dll_u_control__1684_/B VPWR VGND
+ sg13cmos5l_buf_1
XFILLER_11_345 VPWR VGND sg13cmos5l_decap_8
Xu_dll_u_control__2189_ u_dll_u_control__2189_/Q clkload7/A u_dll_u_control__2189_/D
+ u_dll_u_control__2046_/Y VPWR VGND sg13cmos5l_dfrbpq_1
Xu_dll_u_ring_dstage\[0\].id_core_delaybuf1_u_buf u_dll_u_ring_dstage\[0\].id_core_delayinv1_u_inv/A
+ u_dll_u_ring_dstage\[0\].id_core_delaymux1_u_a1/A VPWR VGND sg13cmos5l_buf_1
Xu_dll_u_control__2258_ u_dll_u_control__2258_/Q u_dll_u_control__2271_/CLK u_dll_u_control__2258_/D
+ u_dll_u_control__2115_/Y VPWR VGND sg13cmos5l_dfrbpq_1
Xu_dll_u_div0__056_ u_dll_u_div0__056_/Y u_dll_u_div0__056_/A VPWR VGND sg13cmos5l_inv_1
XFILLER_46_275 VPWR VGND sg13cmos5l_fill_1
Xu_dll_u_ring_dstage\[4\].id_core_slow_isolation_u_buf u_dll_u_ring_dstage\[4\].id_core_delaymux1_u_a1/A
+ u_dll_u_ring_dstage\[3\].id_core_reset_gate_u_aoi/Y VPWR VGND sg13cmos5l_buf_2
Xu_dll_u_control__1560_ u_dll_u_control__1562_/B u_dll_u_control__1560_/A u_dll_u_control__1560_/B
+ u_dll_u_control__1560_/C u_dll_u_control__1560_/D VPWR VGND sg13cmos5l_nand4_1
XFILLER_28_0 VPWR VGND sg13cmos5l_fill_2
Xu_dll_u_ring_dstage\[3\].id_core_long_gate_u_nand u_dll_u_ring_dstage\[3\].id_core_long_gate_u_nand/Y
+ u_dll_u_ring_dstage\[3\].id_core_long_gate_u_nand/A u_dll_u_ring_dstage\[3\].id_core_long_gate_u_nand/B
+ VPWR VGND sg13cmos5l_nand2_2
Xu_dll_u_control__1491_ u_dll_u_control__1493_/B u_dll_u_control__2186_/Q u_dll_u_control__1506_/B
+ VPWR VGND sg13cmos5l_nor2_1
Xu_dll_u_control__2043_ u_dll_u_control__2043_/Y u_dll_u_control__2056_/A VPWR VGND
+ sg13cmos5l_inv_1
Xu_dll_u_control__2112_ u_dll_u_control__2112_/Y u_dll_u_control__2118_/A VPWR VGND
+ sg13cmos5l_inv_1
Xu_dll_u_control__1758_ u_dll_u_control__1758_/Y u_dll_u_control__2224_/Q u_dll_u_control__1752_/A
+ u_dll_u_control__1533_/Y u_dll_u_control__1742_/A VPWR VGND sg13cmos5l_a22oi_1
Xu_dll_u_control__1689_ u_dll_u_control__2284_/D u_dll_u_control__1846_/A u_dll_u_control__1876_/A
+ VPWR VGND sg13cmos5l_nor2_1
XFILLER_28_231 VPWR VGND sg13cmos5l_fill_1
Xu_dll_u_control__1827_ u_dll_u_control__1841_/D u_dll_u_control__1834_/B u_dll_u_control__1827_/B
+ VPWR VGND sg13cmos5l_nor2_1
XFILLER_43_212 VPWR VGND sg13cmos5l_fill_2
XFILLER_43_201 VPWR VGND sg13cmos5l_decap_4
Xu_dll_u_div0__108_ u_dll_u_div0__108_/Q u_dll_u_div0__110_/CLK u_dll_u_div0__113_/Q
+ u_dll_u_div0_fanout59/X VPWR VGND sg13cmos5l_dfrbpq_1
Xu_dll__20_ u_dll__20_/Y u_dll__26_/A u_dll__26_/B VPWR VGND sg13cmos5l_nand2_1
XFILLER_8_73 VPWR VGND sg13cmos5l_fill_1
Xu_dll_u_control__1612_ u_dll_u_control__1718_/A u_dll_u_control__1560_/A u_dll_u_control__1612_/B
+ VPWR VGND sg13cmos5l_nand2b_1
Xu_dll_u_control__1543_ u_dll_u_control__1545_/A u_dll_u_control__2224_/Q u_dll_u_control__1538_/Y
+ u_dll_u_control__1728_/A u_dll_u_control__1537_/Y VPWR VGND sg13cmos5l_a22oi_1
Xu_dll_u_control__1474_ u_dll_u_control__1475_/C u_dll_u_control__2164_/Q u_dll_u_control__1507_/B
+ VPWR VGND sg13cmos5l_nor2_1
XFILLER_25_256 VPWR VGND sg13cmos5l_fill_1
XFILLER_4_105 VPWR VGND sg13cmos5l_fill_1
Xu_dll_u_control__2026_ u_dll_u_control__2026_/Y u_dll_fanout80/X VPWR VGND sg13cmos5l_inv_1
XFILLER_4_116 VPWR VGND sg13cmos5l_fill_1
XFILLER_16_212 VPWR VGND sg13cmos5l_decap_8
XFILLER_16_256 VPWR VGND sg13cmos5l_fill_2
Xu_dll_u_ring_dstage\[11\].id_core_delaybuf1_u_buf u_dll_u_ring_dstage\[11\].id_core_delayinv1_u_inv/A
+ u_dll_u_ring_dstage\[11\].id_core_delaymux1_u_a1/A VPWR VGND sg13cmos5l_buf_1
Xu_dll_u_control_fanout93 u_dll_u_control__1996_/A u_dll_u_control__1999_/A VPWR VGND
+ sg13cmos5l_buf_1
XFILLER_39_326 VPWR VGND sg13cmos5l_decap_4
Xu_dll_u_control_fanout71 u_dll_u_control__2042_/A u_dll_u_control__2048_/A VPWR VGND
+ sg13cmos5l_buf_1
Xu_dll_u_control__1190_ u_dll_u_control__1207_/A u_dll_u_control__1190_/A VPWR VGND
+ sg13cmos5l_inv_1
XFILLER_30_281 VPWR VGND sg13cmos5l_fill_2
XFILLER_22_226 VPWR VGND sg13cmos5l_decap_8
Xu_dll_u_ring_dstage\[11\].id_core_short_gate_u_nand u_dll_u_ring_dstage\[11\].id_core_short_gate_u_nand/Y
+ u_dll_u_ring_dstage\[10\].id_core_reset_gate_u_aoi/Y u_dll_u_ring_dstage\[11\].id_core_short_gate_u_nand/B
+ VPWR VGND sg13cmos5l_nand2_1
XFILLER_38_370 VPWR VGND sg13cmos5l_fill_1
XFILLER_38_15 VPWR VGND sg13cmos5l_decap_8
Xu_dll_u_control__1457_ u_dll_u_control__1458_/C u_dll_u_control__2169_/Q u_dll_u_control__1460_/A
+ VPWR VGND sg13cmos5l_nor2_1
Xu_dll_u_control__1526_ u_dll_u_control__1526_/X u_dll_u_control__1526_/A u_dll_u_control__2234_/Q
+ u_dll_u_control__2235_/Q u_dll_u_control__2236_/Q VPWR VGND sg13cmos5l_or4_1
Xu_dll_u_control__1388_ u_dll_u_control__1388_/Y u_dll_u_control__2192_/Q u_dll_u_control__1392_/B
+ VPWR VGND sg13cmos5l_nand2_1
XFILLER_9_219 VPWR VGND sg13cmos5l_fill_1
Xu_dll_u_control__2009_ u_dll_u_control__2009_/Y u_dll_u_control__2099_/A VPWR VGND
+ sg13cmos5l_inv_1
Xu_dll_u_div1__071_ u_dll_u_div1__071_/Y u_dll_u_div1__071_/A u_dll_u_div1__071_/B
+ u_dll_u_div1__071_/C VPWR VGND sg13cmos5l_nor3_1
XFILLER_0_196 VPWR VGND sg13cmos5l_fill_1
Xheichips26_multimode_dll_small_113 uio_out[4] VPWR VGND sg13cmos5l_tielo
Xheichips26_multimode_dll_small_102 uio_oe[1] VPWR VGND sg13cmos5l_tielo
XFILLER_44_340 VPWR VGND sg13cmos5l_fill_2
XFILLER_36_307 VPWR VGND sg13cmos5l_decap_8
XFILLER_29_370 VPWR VGND sg13cmos5l_fill_2
Xu_dll_u_control__1311_ u_dll_u_control__1469_/B u_dll_u_control__2320_/Q u_dll_u_control__1301_/Y
+ u_dll_u_control__1310_/Y VPWR VGND sg13cmos5l_o21ai_1
Xu_dll_u_control__1173_ u_dll_u_control__1228_/A u_dll_u_control__1169_/Y u_dll_u_control__1172_/Y
+ u_dll_u_control__1149_/X VPWR VGND sg13cmos5l_a21oi_1
XFILLER_35_384 VPWR VGND sg13cmos5l_fill_1
Xu_dll_u_control__1242_ u_dll_u_control__1242_/X u_dll_u_control__1191_/A u_dll_u_control__1241_/X
+ u_dll_u_control__1247_/A VPWR VGND sg13cmos5l_mux2_1
Xu_dll_u_control__2291_ u_dll_u_control__2291_/Q u_dll_u_control__2296_/CLK u_dll_u_control__2291_/D
+ u_dll_u_control__1951_/Y VPWR VGND sg13cmos5l_dfrbpq_1
XFILLER_40_27 VPWR VGND sg13cmos5l_fill_2
Xu_dll_u_ring_dstage\[8\].id_core_delayinv1_u_inv u_dll_u_ring_dstage\[8\].id_core_delayinv1_u_inv/Y
+ u_dll_u_ring_dstage\[8\].id_core_delayinv1_u_inv/A VPWR VGND sg13cmos5l_inv_2
Xu_dll_u_control__1509_ u_dll_u_control__1719_/B u_dll_u_control__2223_/Q u_dll_u_control__1741_/B
+ VPWR VGND sg13cmos5l_nor2_1
XFILLER_41_398 VPWR VGND sg13cmos5l_decap_4
XFILLER_5_288 VPWR VGND sg13cmos5l_fill_1
XFILLER_5_277 VPWR VGND sg13cmos5l_decap_8
Xu_dll_u_div1__054_ u_dll_u_div1__054_/Y u_dll_u_div1__106_/Q VPWR VGND sg13cmos5l_inv_1
XFILLER_32_365 VPWR VGND sg13cmos5l_fill_2
XFILLER_32_354 VPWR VGND sg13cmos5l_decap_8
XFILLER_32_321 VPWR VGND sg13cmos5l_decap_8
Xu_dll_u_control__1860_ u_dll_u_control__1860_/X u_dll_u_control__1860_/A u_dll_u_control__1860_/B
+ VPWR VGND sg13cmos5l_or2_1
Xu_dll_u_control__1791_ u_dll_u_control__2224_/D u_dll_u_control__2153_/Q u_dll_u_control__1797_/B
+ VPWR VGND sg13cmos5l_and2_1
Xu_dll_u_control__2274_ u_dll_u_control__2274_/Q u_dll_u_control__2274_/CLK u_dll_u_control__2274_/D
+ u_dll_u_control__1934_/Y VPWR VGND sg13cmos5l_dfrbpq_1
Xu_dll_u_control__1087_ u_dll_u_control__1552_/B u_dll_u_control__2142_/Q VPWR VGND
+ sg13cmos5l_inv_1
Xu_dll_u_control__1156_ u_dll_u_control__1156_/Y u_dll_u_control__1156_/A VPWR VGND
+ sg13cmos5l_inv_1
Xu_dll_u_control__1225_ u_dll_u_control__1225_/X u_dll_u_control__1814_/A u_dll_u_control__1225_/B
+ VPWR VGND sg13cmos5l_and2_1
XFILLER_23_376 VPWR VGND sg13cmos5l_fill_1
Xu_dll_u_control__1989_ u_dll_u_control__1989_/Y u_dll_u_control__2095_/A VPWR VGND
+ sg13cmos5l_inv_1
Xu_dll_u_div0__072_ u_dll_u_div0__072_/Y u_dll_u_div0__110_/Q u_dll_u_div0__072_/B
+ VPWR VGND sg13cmos5l_xnor2_1
XFILLER_2_236 VPWR VGND sg13cmos5l_fill_2
XFILLER_41_195 VPWR VGND sg13cmos5l_decap_8
Xclkbuf_3_5_0_u_dll\_controller_ring_clk clkbuf_3_5_0_u_dll\_controller_ring_clk/X
+ clkbuf_3_7_0_u_dll\_controller_ring_clk/A VPWR VGND sg13cmos5l_buf_8
XFILLER_25_82 VPWR VGND sg13cmos5l_fill_2
Xu_dll_u_div1__106_ u_dll_u_div1__106_/Q u_dll_u_div1__110_/CLK u_dll_u_div1__111_/Q
+ u_dll_u_div1_fanout60/X VPWR VGND sg13cmos5l_dfrbpq_1
XFILLER_37_402 VPWR VGND sg13cmos5l_fill_2
Xu_dll_u_control__1843_ u_dll_u_control__1855_/B u_dll_u_control__1834_/C u_dll_u_control__1846_/D
+ u_dll_u_control__1825_/Y u_dll_u_control__1867_/A u_dll_u_control__1687_/B VPWR
+ VGND sg13cmos5l_a221oi_1
Xu_dll_u_control__1912_ u_dll_u_control__2305_/D u_dll_u_control__1899_/B u_dll_u_control__1909_/B
+ u_dll_u_control__1911_/Y VPWR VGND sg13cmos5l_a21oi_1
XFILLER_9_380 VPWR VGND sg13cmos5l_fill_1
Xclkbuf_5_20__f_u_dll\_controller_ref_clk u_dll_u_control__2266_/CLK clkbuf_4_10_0_u_dll\_controller_ref_clk/X
+ VPWR VGND sg13cmos5l_buf_8
Xu_dll_u_control__1774_ u_dll_u_control__1774_/Y u_dll_u_control__1605_/C u_dll_u_control__1724_/B
+ u_dll_u_control__1783_/A VPWR VGND sg13cmos5l_o21ai_1
Xu_dll_u_control__2257_ u_dll_u_control__2257_/Q clkload1/A u_dll_u_control__2257_/D
+ u_dll_u_control__2114_/Y VPWR VGND sg13cmos5l_dfrbpq_1
Xu_dll_u_control__1139_ u_dll_u_control__1147_/C u_dll_u_control__1552_/B u_dll_u_control__1151_/B
+ u_dll_u_control__2143_/Q VPWR VGND sg13cmos5l_a21o_1
Xu_dll_u_control__1208_ u_dll_u_control__1851_/A u_dll_u_control__1205_/Y u_dll_u_control__1206_/Y
+ u_dll_u_control__1207_/Y VPWR VGND sg13cmos5l_a21o_1
Xu_dll_u_control_fanout4 u_dll_u_control__1841_/C u_dll_u_control__1833_/C VPWR VGND
+ sg13cmos5l_buf_1
Xu_dll_u_ring_trim_reset_buffers\[1\].u_buffer_u_buf u_dll_u_ring_trim_reset_buffers\[1\].u_buffer_u_buf/X
+ u_dll_u_ring_reset_buffer_u_buf/X VPWR VGND sg13cmos5l_buf_4
Xu_dll_u_control__2188_ u_dll_u_control__2188_/Q clkload7/A u_dll_u_control__2188_/D
+ u_dll_u_control__2045_/Y VPWR VGND sg13cmos5l_dfrbpq_1
Xu_dll_u_div0__055_ u_dll_u_div0__060_/D u_dll_u_div0__107_/Q VPWR VGND sg13cmos5l_inv_1
XFILLER_11_40 VPWR VGND sg13cmos5l_fill_1
XFILLER_36_81 VPWR VGND sg13cmos5l_fill_1
Xu_dll_u_ring_dstage\[10\].id_core_trim_sync\[0\].applied_u_ff u_dll_u_ring_dstage\[10\].id_core_delaymux1_u_a1/B
+ u_dll_u_ring_dstage\[10\].id_core_delayinv1_u_inv/Y u_dll_u_ring_dstage\[10\].id_core_trim_sync\[0\].meta_u_ff/Q
+ u_dll_u_ring_dstage\[10\].id_core_trim_reset_inv_u_inv/Y VPWR VGND sg13cmos5l_dfrbpq_1
Xu_dll_u_control__1490_ u_dll_u_control__2159_/D u_dll_u_control__1508_/A u_dll_u_control__1490_/B
+ u_dll_u_control__1490_/C VPWR VGND sg13cmos5l_nor3_1
XFILLER_37_287 VPWR VGND sg13cmos5l_decap_8
Xu_dll_u_control__2111_ u_dll_u_control__2111_/Y u_dll_u_control__2124_/A VPWR VGND
+ sg13cmos5l_inv_1
Xu_dll_u_ring_dstage\[2\].id_core_delaymux1_u_a0 u_dll_u_ring_dstage\[2\].id_core_delaymux1_u_a0/Y
+ u_dll_u_ring_dstage\[2\].id_core_delaymux1_u_a0/A u_dll_u_ring_dstage\[2\].id_core_delaymux1_u_a0/B
+ VPWR VGND sg13cmos5l_nand2_2
Xu_dll_u_control__2042_ u_dll_u_control__2042_/Y u_dll_u_control__2042_/A VPWR VGND
+ sg13cmos5l_inv_1
Xu_dll_u_control__1826_ u_dll_u_control__1826_/X u_dll_u_control__1238_/A u_dll_u_control__1287_/Y
+ u_dll_u_control__1825_/Y VPWR VGND sg13cmos5l_a21o_1
XFILLER_4_309 VPWR VGND sg13cmos5l_decap_8
Xu_dll_u_control__1757_ u_dll_u_control__1757_/Y u_dll_u_control__1537_/B u_dll_u_control__1728_/A
+ u_dll_u_control__1724_/B u_dll_u_control__1772_/B VPWR VGND sg13cmos5l_a22oi_1
Xu_dll_u_control__1688_ u_dll_u_control__2271_/D u_dll_u_control__1686_/Y u_dll_u_control__1687_/Y
+ u_dll_u_control__1280_/A VPWR VGND sg13cmos5l_o21ai_1
Xu_dll_u_ring_dstage\[7\].id_core_reset_gate_u_aoi u_dll_u_ring_dstage\[7\].id_core_reset_gate_u_aoi/Y
+ u_dll_u_ring_dstage\[6\].id_core_reset_gate_u_aoi/Y u_dll_u_ring_dstage\[7\].id_core_reset_gate_u_aoi/A2
+ u_dll_u_ring_dstage\[7\].id_core_reset_gate_u_aoi/B1 VPWR VGND sg13cmos5l_a21oi_2
Xu_dll_u_control__2309_ u_dll_u_control__2309_/Q u_dll_u_control__2309_/CLK u_dll_u_control__2309_/D
+ u_dll_u_control__1969_/Y VPWR VGND sg13cmos5l_dfrbpq_1
Xu_dll_u_div0__107_ u_dll_u_div0__107_/Q u_dll_u_div0__110_/CLK u_dll_u_div0__107_/D
+ u_dll_u_div0_fanout59/X VPWR VGND sg13cmos5l_dfrbpq_1
XFILLER_3_386 VPWR VGND sg13cmos5l_decap_8
XFILLER_21_8 VPWR VGND sg13cmos5l_fill_2
Xu_dll_u_div1_u_clkbuf_out_u_buf u_pad1_u_buf/A u_dll_u_div1_u_clkbuf_out_u_buf/A
+ VPWR VGND sg13cmos5l_buf_16
XFILLER_19_298 VPWR VGND sg13cmos5l_fill_1
Xclkbuf_4_11__f_u_dll\_controller_ring_clk u_dll_u_control__2172_/CLK clkbuf_3_5_0_u_dll\_controller_ring_clk/X
+ VPWR VGND sg13cmos5l_buf_8
Xu_dll_u_control__1542_ u_dll_u_control__1542_/Y u_dll_u_control__1724_/B u_dll_u_control__1926_/A
+ VPWR VGND sg13cmos5l_nand2b_1
Xu_dll_u_control__1611_ u_dll_u_control__1612_/B u_dll_u_control__1679_/B u_dll_u_control__1610_/Y
+ VPWR VGND sg13cmos5l_nor2b_1
Xu_dll_u_control__1473_ u_dll_u_control__1475_/B u_dll_u_control__2192_/Q u_dll_u_control__1485_/B
+ VPWR VGND sg13cmos5l_nor2_1
XFILLER_43_49 VPWR VGND sg13cmos5l_fill_1
XFILLER_40_238 VPWR VGND sg13cmos5l_decap_8
XFILLER_40_216 VPWR VGND sg13cmos5l_fill_1
Xu_dll_u_control__2025_ u_dll_u_control__2025_/Y u_dll_fanout80/X VPWR VGND sg13cmos5l_inv_1
Xclkbuf_5_8__f_u_dll\_controller_ref_clk u_dll_u_control__2227_/CLK clkbuf_4_4_0_u_dll\_controller_ref_clk/X
+ VPWR VGND sg13cmos5l_buf_8
Xu_dll_u_control__1809_ u_dll_u_control__2233_/D u_dll_u_control__1809_/A u_dll_u_control__1809_/B
+ u_dll_u_control__1809_/C VPWR VGND sg13cmos5l_nor3_1
Xu_dll_u_ring_dstage\[9\].id_core_trim_sync\[1\].meta_u_ff u_dll_u_ring_dstage\[9\].id_core_trim_sync\[1\].meta_u_ff/Q
+ u_dll_u_ring_dstage\[9\].id_core_delayinv1_u_inv/Y u_dll_u_control__1069_/Y u_dll_u_ring_dstage\[9\].id_core_trim_reset_inv_u_inv/Y
+ VPWR VGND sg13cmos5l_dfrbpq_1
XFILLER_16_246 VPWR VGND sg13cmos5l_decap_4
Xu_dll_u_control_fanout94 u_dll_u_control__1999_/A u_dll_u_control__2002_/A VPWR VGND
+ sg13cmos5l_buf_1
Xu_dll_u_control_fanout83 u_dll_u_control__2083_/A u_dll_u_control__2090_/A VPWR VGND
+ sg13cmos5l_buf_1
Xu_dll_u_control_fanout50 u_dll_u_control__1814_/A u_dll_u_control__1679_/A VPWR VGND
+ sg13cmos5l_buf_1
Xu_dll_u_control_fanout72 u_dll_u_control__2085_/A u_dll_u_control__2048_/A VPWR VGND
+ sg13cmos5l_buf_1
Xu_dll_u_ring_dstage\[0\].id_core_trim_reset_inv_u_inv u_dll_u_ring_dstage\[0\].id_core_trim_reset_inv_u_inv/Y
+ u_dll_u_ring_trim_reset_buffers\[0\].u_buffer_u_buf/X VPWR VGND sg13cmos5l_inv_2
XFILLER_38_49 VPWR VGND sg13cmos5l_fill_2
Xu_dll_u_control__1456_ u_dll_u_control__2170_/D u_dll_u_control__1456_/A u_dll_u_control__1456_/B
+ u_dll_u_control__1456_/C VPWR VGND sg13cmos5l_nor3_1
Xu_dll_u_control__1525_ u_dll_u_control__1525_/Y u_dll_u_control__2234_/Q u_dll_u_control__2235_/Q
+ u_dll_u_control__2236_/Q u_dll_u_control__1525_/D VPWR VGND sg13cmos5l_nand4_1
Xu_dll_u_control__2008_ u_dll_u_control__2008_/Y u_dll_u_control__2102_/A VPWR VGND
+ sg13cmos5l_inv_1
Xu_dll_u_control__1387_ u_dll_u_control__2193_/D u_dll_u_control__2193_/Q u_dll_u_control__1392_/B
+ u_dll_u_control__1386_/Y VPWR VGND sg13cmos5l_a21o_1
Xu_dll_u_div1__070_ u_dll_u_div1__071_/C u_dll_u_div1__070_/A u_dll_u_div1__070_/B
+ VPWR VGND sg13cmos5l_nor2_1
Xheichips26_multimode_dll_small_114 uio_out[5] VPWR VGND sg13cmos5l_tielo
Xheichips26_multimode_dll_small_103 uio_oe[2] VPWR VGND sg13cmos5l_tielo
XFILLER_44_385 VPWR VGND sg13cmos5l_decap_8
Xu_dll_u_div0_u_run_gate_u_and u_dll_u_div0_u_run_gate_u_and/X u_dll_u_div0_u_run_gate_u_and/A
+ u_dll_u_div0__105_/RESET_B VPWR VGND sg13cmos5l_and2_2
XFILLER_5_86 VPWR VGND sg13cmos5l_fill_1
Xu_dll_u_control__1241_ u_dll_u_control__1241_/X u_dll_u_control__1241_/A u_dll_u_control__1241_/B
+ VPWR VGND sg13cmos5l_and2_1
Xu_dll_u_control__1310_ u_dll_u_control__1310_/Y u_dll_u_control__1310_/A u_dll_u_control__1310_/B
+ u_dll_u_control__1310_/C VPWR VGND sg13cmos5l_nor3_1
Xu_dll_u_control__2290_ u_dll_u_control__2290_/Q u_dll_u_control__2300_/CLK u_dll_u_control__2290_/D
+ u_dll_u_control__1950_/Y VPWR VGND sg13cmos5l_dfrbpq_1
Xu_dll_u_control__1172_ u_dll_u_control__1172_/Y u_dll_u_control__1172_/A u_dll_u_control__1172_/B
+ VPWR VGND sg13cmos5l_nor2_1
XFILLER_35_396 VPWR VGND sg13cmos5l_decap_8
XFILLER_35_363 VPWR VGND sg13cmos5l_decap_8
XFILLER_10_219 VPWR VGND sg13cmos5l_fill_1
XFILLER_41_300 VPWR VGND sg13cmos5l_fill_1
Xu_dll_u_control__1439_ u_dll_u_control__1439_/Y u_dll_u_control__2175_/Q u_dll_u_control__1442_/B
+ u_dll_u_control__1420_/B VPWR VGND sg13cmos5l_o21ai_1
XFILLER_18_319 VPWR VGND sg13cmos5l_fill_2
Xu_dll_u_control__1508_ u_dll_u_control__2153_/D u_dll_u_control__1508_/A u_dll_u_control__1508_/B
+ u_dll_u_control__1508_/C VPWR VGND sg13cmos5l_nor3_1
XFILLER_26_363 VPWR VGND sg13cmos5l_fill_1
XFILLER_41_377 VPWR VGND sg13cmos5l_fill_2
XFILLER_5_212 VPWR VGND sg13cmos5l_decap_4
XFILLER_5_256 VPWR VGND sg13cmos5l_decap_8
Xu_dll_u_div1__053_ u_dll_u_div1__085_/A u_dll_u_div1__104_/Q VPWR VGND sg13cmos5l_inv_1
XFILLER_17_330 VPWR VGND sg13cmos5l_fill_2
Xclkbuf_5_19__f_u_dll\_controller_ref_clk u_dll_u_control__2280_/CLK clkbuf_4_9_0_u_dll\_controller_ref_clk/X
+ VPWR VGND sg13cmos5l_buf_8
Xu_dll_u_control__1790_ u_dll_u_control__2244_/D u_dll_u_control__1679_/A u_dll_u_control__1788_/A
+ u_dll_u_control__2245_/D VPWR VGND sg13cmos5l_a21o_1
Xu_dll_u_control__2273_ u_dll_u_control__2273_/Q u_dll_u_control__2316_/CLK u_dll_u_control__2273_/D
+ u_dll_u_control__1933_/Y VPWR VGND sg13cmos5l_dfrbpq_1
Xu_dll_u_control__1224_ u_dll_u_control__1867_/A u_dll_u_control__1224_/A u_dll_u_control__1224_/B
+ VPWR VGND sg13cmos5l_nand2_1
Xu_dll_u_ring_dstage\[5\].id_core_slow_isolation_u_buf u_dll_u_ring_dstage\[5\].id_core_delaymux1_u_a1/A
+ u_dll_u_ring_dstage\[4\].id_core_reset_gate_u_aoi/Y VPWR VGND sg13cmos5l_buf_2
Xu_dll_u_control__1155_ u_dll_u_control__1156_/A u_dll_u_control__2141_/Q u_dll_u_control__2281_/Q
+ u_dll_u_control__1183_/A VPWR VGND sg13cmos5l_o21ai_1
Xu_dll_u_control__1086_ u_dll_u_control__1165_/A u_dll_u_control__1618_/A VPWR VGND
+ sg13cmos5l_inv_1
Xu_dll_u_div0__071_ u_dll_u_div0__071_/Y u_dll_u_div0__071_/A u_dll_u_div0__071_/B
+ u_dll_u_div0__071_/C VPWR VGND sg13cmos5l_nor3_1
XFILLER_2_226 VPWR VGND sg13cmos5l_fill_1
Xu_dll_u_control__1988_ u_dll_u_control__1988_/Y u_dll_u_control__2090_/A VPWR VGND
+ sg13cmos5l_inv_1
XFILLER_46_403 VPWR VGND sg13cmos5l_fill_1
Xu_dll_u_div0_u_parity_mux_u_a0 u_dll_u_div0_u_parity_mux_u_a0/Y u_dll_u_div0__100_/D
+ u_dll_u_div0_u_parity_mux_u_a0/B VPWR VGND sg13cmos5l_nand2_2
Xclkbuf_4_7__f_u_dll\_controller_ring_clk clkload7/A clkbuf_3_3_0_u_dll\_controller_ring_clk/X
+ VPWR VGND sg13cmos5l_buf_8
XFILLER_14_399 VPWR VGND sg13cmos5l_decap_4
Xu_dll_u_div1__105_ u_dll_u_div1__105_/Q u_dll_u_div1__056_/A u_dll_u_div1__105_/D
+ u_dll_u_div1__105_/RESET_B VPWR VGND sg13cmos5l_dfrbpq_1
XFILLER_32_185 VPWR VGND sg13cmos5l_fill_1
Xu_dll_u_control__1773_ u_dll_u_control__1773_/Y u_dll_u_control__1299_/A u_dll_u_control__1531_/B
+ u_dll_u_control__1533_/Y u_dll_u_control__1537_/B u_dll_u_control__1752_/A VPWR
+ VGND sg13cmos5l_a221oi_1
Xu_dll_u_control__1911_ u_dll_u_control__1911_/Y u_dll_u_control__1899_/B u_dll_u_control__1909_/B
+ u_dll_u_control__1909_/A VPWR VGND sg13cmos5l_o21ai_1
Xu_dll_u_control__1842_ u_dll_u_control__2255_/D u_dll_u_control__1238_/A u_dll_u_control__1851_/C
+ u_dll_u_control__1837_/Y u_dll_u_control__1841_/Y u_dll_u_control__1859_/B VPWR
+ VGND sg13cmos5l_a221oi_1
Xu_dll_u_control__1207_ u_dll_u_control__1207_/Y u_dll_u_control__1207_/A u_dll_u_control__1245_/S
+ VPWR VGND sg13cmos5l_nor2_1
Xu_dll_u_control__2256_ u_dll_u_control__2256_/Q clkload5/A u_dll_u_control__2256_/D
+ u_dll_u_control__2113_/Y VPWR VGND sg13cmos5l_dfrbpq_1
Xu_dll_u_control__2187_ u_dll_u_control__2187_/Q u_dll_u_control__2206_/CLK u_dll_u_control__2187_/D
+ u_dll_u_control__2044_/Y VPWR VGND sg13cmos5l_dfrbpq_1
Xu_dll_u_control__1138_ u_dll_u_control__1163_/A u_dll_u_control__2144_/Q u_dll_u_control__1147_/B
+ VPWR VGND sg13cmos5l_xnor2_1
Xu_dll_u_div0__054_ u_dll_u_div0__054_/Y u_dll_u_div0__106_/Q VPWR VGND sg13cmos5l_inv_1
Xu_dll_u_control_fanout5 u_dll_u_control__1859_/A u_dll_u_control__1857_/A VPWR VGND
+ sg13cmos5l_buf_1
Xu_dll_u_control__1069_ u_dll_u_control__1069_/Y u_dll_u_control__2268_/Q VPWR VGND
+ sg13cmos5l_inv_1
XFILLER_19_403 VPWR VGND sg13cmos5l_fill_1
XFILLER_36_93 VPWR VGND sg13cmos5l_fill_1
XFILLER_14_196 VPWR VGND sg13cmos5l_fill_2
XFILLER_6_395 VPWR VGND sg13cmos5l_decap_8
Xu_dll_u_ring_dstage\[0\].id_core_delayint0_u_inv u_dll_u_ring_dstage\[0\].id_core_delaymux1_u_a0/A
+ u_dll_u_ring_dstage\[0\].id_core_delayinv1_u_inv/Y VPWR VGND sg13cmos5l_inv_1
Xu_dll_u_ring_dstage\[2\].id_core_delaymux1_u_a1 u_dll_u_ring_dstage\[2\].id_core_delaymux1_u_a1/Y
+ u_dll_u_ring_dstage\[2\].id_core_delaymux1_u_a1/A u_dll_u_ring_dstage\[2\].id_core_delaymux1_u_a1/B
+ VPWR VGND sg13cmos5l_nand2_2
Xu_dll_u_control__2110_ u_dll_u_control__2110_/Y u_dll_u_control__2124_/A VPWR VGND
+ sg13cmos5l_inv_1
Xu_dll_u_control__2041_ u_dll_u_control__2041_/Y u_dll_u_control__2042_/A VPWR VGND
+ sg13cmos5l_inv_1
XFILLER_32_29 VPWR VGND sg13cmos5l_fill_2
Xu_dll_u_control__1756_ u_dll_u_control__2239_/D u_dll_u_control__1756_/A u_dll_u_control__1754_/Y
+ VPWR VGND sg13cmos5l_nor2b_1
Xu_dll_u_control__1825_ u_dll_u_control__1825_/Y u_dll_u_control__1851_/A u_dll_u_control__1859_/A
+ u_dll_u_control__1834_/B u_dll_u_control__1846_/B VPWR VGND sg13cmos5l_nor4_1
Xu_dll_u_ring_dstage\[9\].id_core_trim_sync\[0\].meta_u_ff u_dll_u_ring_dstage\[9\].id_core_trim_sync\[0\].meta_u_ff/Q
+ u_dll_u_ring_dstage\[9\].id_core_delayinv1_u_inv/Y u_dll_u_control__2255_/Q u_dll_u_ring_dstage\[9\].id_core_trim_reset_inv_u_inv/Y
+ VPWR VGND sg13cmos5l_dfrbpq_1
Xu_dll_u_control__1687_ u_dll_u_control__1687_/Y u_dll_u_control__1859_/A u_dll_u_control__1687_/B
+ u_dll_u_control__2280_/D VPWR VGND sg13cmos5l_nand3_1
Xu_dll_u_control__2239_ u_dll_u_control__2239_/Q u_dll_u_control__2317_/CLK u_dll_u_control__2239_/D
+ u_dll_u_control__2096_/Y VPWR VGND sg13cmos5l_dfrbpq_1
Xu_dll_u_control__2308_ u_dll_u_control__2308_/Q u_dll_u_control__2308_/CLK u_dll_u_control__2308_/D
+ u_dll_u_control__1968_/Y VPWR VGND sg13cmos5l_dfrbpq_1
Xu_dll_u_ring_dstage\[4\].id_core_trim_sync\[1\].meta_u_ff u_dll_u_ring_dstage\[4\].id_core_trim_sync\[1\].meta_u_ff/Q
+ u_dll_u_ring_dstage\[4\].id_core_delayinv1_u_inv/Y u_dll_u_control__1074_/Y u_dll_u_ring_dstage\[4\].id_core_trim_reset_inv_u_inv/Y
+ VPWR VGND sg13cmos5l_dfrbpq_1
Xu_dll_u_div0__106_ u_dll_u_div0__106_/Q u_dll_u_div0__110_/CLK u_dll_u_div0__111_/Q
+ u_dll_u_div0_fanout59/X VPWR VGND sg13cmos5l_dfrbpq_1
XFILLER_3_354 VPWR VGND sg13cmos5l_fill_2
XFILLER_0_0 VPWR VGND sg13cmos5l_decap_8
Xu_dll_u_ring_iss_core_reset_gate_u_aoi u_dll_u_ring_u_output_inv0_u_inv/A u_dll_u_ring_iss_core_short_gate_u_nand/A
+ u_dll_u_ring_iss_core_reset_gate_u_aoi/A2 u_dll_u_ring_iss_core_reset_gate_u_aoi/B1
+ VPWR VGND sg13cmos5l_a21oi_2
XFILLER_34_203 VPWR VGND sg13cmos5l_decap_8
Xu_dll_u_ring_dstage\[8\].id_core_long_gate_u_nand u_dll_u_ring_dstage\[8\].id_core_long_gate_u_nand/Y
+ u_dll_u_ring_dstage\[8\].id_core_long_gate_u_nand/A u_dll_u_ring_dstage\[8\].id_core_long_gate_u_nand/B
+ VPWR VGND sg13cmos5l_nand2_2
XFILLER_33_0 VPWR VGND sg13cmos5l_fill_2
Xu_dll_u_control__1610_ u_dll_u_control__1610_/Y u_dll_u_control__1610_/A u_dll_u_control__1610_/B
+ u_dll_u_control__1610_/C u_dll_u_control__1610_/D VPWR VGND sg13cmos5l_nand4_1
Xu_dll_u_control__1541_ u_dll_u_control__1724_/B u_dll_u_control__2226_/Q u_dll_u_control__1541_/B
+ VPWR VGND sg13cmos5l_xnor2_1
Xu_dll_u_control__1472_ u_dll_u_control__2165_/D u_dll_u_control__1472_/A u_dll_u_control__1508_/A
+ u_dll_u_control__1472_/C VPWR VGND sg13cmos5l_nor3_1
Xu_dll_u_control__2024_ u_dll_u_control__2024_/Y u_dll_fanout80/X VPWR VGND sg13cmos5l_inv_1
Xu_dll_u_control__1739_ u_dll_u_control__1739_/Y u_dll_u_control__2221_/Q u_dll_u_control__2208_/Q
+ VPWR VGND sg13cmos5l_nor2b_1
XFILLER_0_379 VPWR VGND sg13cmos5l_decap_8
Xu_dll_u_control__1808_ u_dll_u_control__1809_/C u_dll_u_control__1808_/A u_dll_u_control__1808_/B
+ VPWR VGND sg13cmos5l_nor2_1
XFILLER_33_61 VPWR VGND sg13cmos5l_fill_1
XFILLER_31_228 VPWR VGND sg13cmos5l_fill_1
Xu_dll_u_control_fanout51 u_dll_u_control__1679_/A u_dll_u_control__2317_/Q VPWR VGND
+ sg13cmos5l_buf_1
Xu_dll_u_control_fanout84 u_dll_u_control__2082_/A u_dll_u_control__2090_/A VPWR VGND
+ sg13cmos5l_buf_1
Xu_dll_u_control_fanout95 u_dll_u_control__2002_/A u_dll_u_control_fanout96/X VPWR
+ VGND sg13cmos5l_buf_1
Xu_dll_u_control_fanout62 u_dll_u_control__2060_/A u_dll_u_control__2063_/A VPWR VGND
+ sg13cmos5l_buf_1
Xu_dll_u_control_fanout40 u_dll_u_control__1913_/A u_dll_u_control__1092_/Y VPWR VGND
+ sg13cmos5l_buf_1
Xu_dll_u_control_fanout73 u_dll_u_control__2048_/A u_dll_u_control_fanout78/X VPWR
+ VGND sg13cmos5l_buf_1
Xu_dll_u_ring_iss_core_short_gate_u_nand u_dll_u_ring_iss_core_short_gate_u_nand/Y
+ u_dll_u_ring_iss_core_short_gate_u_nand/A u_dll_u_ring_iss_core_short_gate_u_nand/B
+ VPWR VGND sg13cmos5l_nand2_1
XFILLER_30_283 VPWR VGND sg13cmos5l_fill_1
XFILLER_38_394 VPWR VGND sg13cmos5l_decap_8
XFILLER_38_383 VPWR VGND sg13cmos5l_fill_2
Xu_dll_u_control__1455_ u_dll_u_control__1456_/C u_dll_u_control__2170_/Q u_dll_u_control__1458_/B
+ VPWR VGND sg13cmos5l_nor2_1
Xu_dll_u_ring_dstage\[11\].id_core_delayint0_u_inv u_dll_u_ring_dstage\[11\].id_core_delaymux1_u_a0/A
+ u_dll_u_ring_dstage\[11\].id_core_delayinv1_u_inv/Y VPWR VGND sg13cmos5l_inv_1
Xu_dll_u_control__1386_ u_dll_u_control__1386_/Y u_dll_u_control__1386_/A u_dll_u_control__1386_/B
+ u_dll_u_control__1386_/C VPWR VGND sg13cmos5l_nor3_1
Xu_dll_u_control__1524_ u_dll_u_control__1525_/D u_dll_u_control__1526_/A u_dll_u_control__2232_/Q
+ VPWR VGND sg13cmos5l_and2_1
Xu_dll_u_control__2007_ u_dll_u_control__2007_/Y u_dll_u_control__2083_/A VPWR VGND
+ sg13cmos5l_inv_1
Xu_dll_u_ring_dstage\[4\].id_const0_u_hi u_dll_u_ring_dstage\[4\].id_const0_u_hi/L_HI
+ VPWR VGND sg13cmos5l_tiehi
XFILLER_29_361 VPWR VGND sg13cmos5l_fill_1
XFILLER_0_176 VPWR VGND sg13cmos5l_fill_2
Xheichips26_multimode_dll_small_115 uio_out[6] VPWR VGND sg13cmos5l_tielo
Xheichips26_multimode_dll_small_104 uio_oe[3] VPWR VGND sg13cmos5l_tielo
XFILLER_44_364 VPWR VGND sg13cmos5l_decap_8
XFILLER_8_210 VPWR VGND sg13cmos5l_decap_8
XFILLER_35_353 VPWR VGND sg13cmos5l_decap_4
Xu_dll_u_control__1240_ u_dll_u_control__1241_/B u_dll_u_control__2281_/Q u_dll_u_control__1183_/A
+ u_dll_u_control__2282_/Q VPWR VGND sg13cmos5l_a21o_1
Xu_dll_u_control__1171_ u_dll_u_control__1172_/B u_dll_u_control__1227_/A u_dll_u_control__1171_/B
+ VPWR VGND sg13cmos5l_nor2_1
Xu_dll_u_control__1507_ u_dll_u_control__1508_/C u_dll_u_control__2153_/Q u_dll_u_control__1507_/B
+ VPWR VGND sg13cmos5l_nor2_1
Xu_dll_u_control__1438_ u_dll_u_control__2176_/D u_dll_u_control__1456_/A u_dll_u_control__1438_/B
+ u_dll_u_control__1438_/C VPWR VGND sg13cmos5l_nor3_1
Xu_dll_u_control__1369_ u_dll_u_control__2198_/D u_dll_u_control__1384_/A u_dll_u_control__1369_/B
+ u_dll_u_control__1369_/C VPWR VGND sg13cmos5l_nor3_1
XFILLER_5_235 VPWR VGND sg13cmos5l_decap_8
XFILLER_5_224 VPWR VGND sg13cmos5l_fill_2
Xu_dll_u_div1__052_ u_dll_u_div1__070_/A u_dll_u_div1__103_/Q VPWR VGND sg13cmos5l_inv_1
XFILLER_32_367 VPWR VGND sg13cmos5l_fill_1
Xu_dll_u_control__2272_ u_dll_u_control__2272_/Q u_dll_u_control__2316_/CLK u_dll_u_control__2272_/D
+ u_dll_u_control__1932_/Y VPWR VGND sg13cmos5l_dfrbpq_1
Xu_dll_u_control__1154_ u_dll_u_control__1154_/Y u_dll_u_control__1097_/Y u_dll_u_control__1153_/Y
+ u_dll_u_control__1152_/S VPWR VGND sg13cmos5l_a21oi_1
Xu_dll_u_control__1223_ u_dll_u_control__1833_/B u_dll_u_control__1224_/A u_dll_u_control__1224_/B
+ VPWR VGND sg13cmos5l_and2_1
XFILLER_27_128 VPWR VGND sg13cmos5l_fill_1
Xu_dll_u_div0__070_ u_dll_u_div0__071_/C u_dll_u_div0__070_/A u_dll_u_div0__070_/B
+ VPWR VGND sg13cmos5l_nor2_1
Xclkbuf_5_25__f_u_dll\_controller_ref_clk clkload6/A clkbuf_4_12_0_u_dll\_controller_ref_clk/X
+ VPWR VGND sg13cmos5l_buf_8
Xu_dll_u_control__1085_ u_dll_u_control__1085_/Y u_dll_u_control__2321_/Q VPWR VGND
+ sg13cmos5l_inv_1
XFILLER_2_249 VPWR VGND sg13cmos5l_fill_1
Xu_dll_u_control__1987_ u_dll_u_control__1987_/Y u_dll_u_control__2093_/A VPWR VGND
+ sg13cmos5l_inv_1
Xu_dll_u_div0_u_parity_mux_u_a1 u_dll_u_div0_u_parity_mux_u_a1/Y u_dll_u_div0_u_parity_mux_u_a1/A
+ u_dll_u_div0__106_/Q VPWR VGND sg13cmos5l_nand2_2
XFILLER_33_109 VPWR VGND sg13cmos5l_fill_2
XFILLER_18_128 VPWR VGND sg13cmos5l_fill_2
XFILLER_41_94 VPWR VGND sg13cmos5l_decap_8
Xu_dll_u_div1__104_ u_dll_u_div1__104_/Q u_dll_u_div1__056_/A u_dll_u_div1__104_/D
+ u_dll_u_div1__105_/RESET_B VPWR VGND sg13cmos5l_dfrbpq_1
XFILLER_2_22 VPWR VGND sg13cmos5l_decap_8
Xu_dll_u_control__1910_ u_dll_u_control__2308_/D u_dll_u_control__1910_/A u_dll_u_control__1910_/B
+ VPWR VGND sg13cmos5l_nor2_1
Xu_dll_u_control__1772_ u_dll_u_control__1772_/Y u_dll_u_control__1772_/A u_dll_u_control__1772_/B
+ VPWR VGND sg13cmos5l_nand2_1
Xu_dll_u_control__1841_ u_dll_u_control__1841_/Y u_dll_u_control__1851_/A u_dll_u_control__1885_/B
+ u_dll_u_control__1841_/C u_dll_u_control__1841_/D VPWR VGND sg13cmos5l_nand4_1
Xu_dll_u_control__2324_ u_dll_u_control__2324_/Q u_dll_u_control__2324_/CLK ui_in[4]
+ u_dll_u_control__1984_/Y VPWR VGND sg13cmos5l_dfrbpq_1
Xu_dll_u_control__1137_ u_dll_u_control__1137_/Y u_dll_u_control__1166_/B u_dll_u_control__1165_/A
+ VPWR VGND sg13cmos5l_nand2b_1
Xu_dll_u_control__1206_ u_dll_u_control__1206_/Y u_dll_u_control__1247_/A u_dll_u_control__1176_/Y
+ u_dll_u_control__1246_/B VPWR VGND sg13cmos5l_a21oi_1
Xu_dll_u_ring_dstage\[9\].id_const0_u_hi u_dll_u_ring_dstage\[9\].id_const0_u_hi/L_HI
+ VPWR VGND sg13cmos5l_tiehi
Xu_dll_u_control__2186_ u_dll_u_control__2186_/Q clkload7/A u_dll_u_control__2186_/D
+ u_dll_u_control__2043_/Y VPWR VGND sg13cmos5l_dfrbpq_1
Xu_dll_u_ring_dstage\[4\].id_core_trim_sync\[0\].meta_u_ff u_dll_u_ring_dstage\[4\].id_core_trim_sync\[0\].meta_u_ff/Q
+ u_dll_u_ring_dstage\[4\].id_core_delayinv1_u_inv/Y u_dll_u_control__2250_/Q u_dll_u_ring_dstage\[4\].id_core_trim_reset_inv_u_inv/Y
+ VPWR VGND sg13cmos5l_dfrbpq_1
Xu_dll_u_control__2255_ u_dll_u_control__2255_/Q u_dll_u_control__2268_/CLK u_dll_u_control__2255_/D
+ u_dll_u_control__2112_/Y VPWR VGND sg13cmos5l_dfrbpq_1
Xu_dll_u_div0__053_ u_dll_u_div0__085_/A u_dll_u_div0__104_/Q VPWR VGND sg13cmos5l_inv_1
Xu_dll_u_control_fanout6 u_dll_u_control__1829_/A u_dll_u_control__1834_/A VPWR VGND
+ sg13cmos5l_buf_1
Xu_dll_u_control__1068_ u_dll_u_control__1068_/Y u_dll_u_control__2269_/Q VPWR VGND
+ sg13cmos5l_inv_1
Xu_dll_u_ring_dstage\[1\].id_core_delayinv1_u_inv u_dll_u_ring_dstage\[1\].id_core_delayinv1_u_inv/Y
+ u_dll_u_ring_dstage\[1\].id_core_delayinv1_u_inv/A VPWR VGND sg13cmos5l_inv_2
XFILLER_46_234 VPWR VGND sg13cmos5l_decap_4
XFILLER_37_245 VPWR VGND sg13cmos5l_fill_2
Xclkbuf_1_1_0_u_dll\_controller_ring_clk clkbuf_3_7_0_u_dll\_controller_ring_clk/A
+ clkbuf_0_u_dll\_controller_ring_clk/X VPWR VGND sg13cmos5l_buf_8
Xu_dll_u_control__2040_ u_dll_u_control__2040_/Y u_dll_u_control__2042_/A VPWR VGND
+ sg13cmos5l_inv_1
Xu_dll_u_control__1755_ u_dll_u_control__1756_/A u_dll_u_control__1750_/Y u_dll_u_control__1760_/B
+ u_dll_u_control__1679_/A VPWR VGND sg13cmos5l_o21ai_1
Xu_dll_u_control__1824_ u_dll_u_control__2236_/D u_dll_u_control__2237_/D u_dll_u_control__1824_/B
+ VPWR VGND sg13cmos5l_nand2b_1
Xu_dll_u_control__1686_ u_dll_u_control__1686_/Y u_dll_u_control__1829_/A u_dll_u_control__1851_/C
+ u_dll_u_control__1686_/C VPWR VGND sg13cmos5l_nand3_1
XFILLER_43_248 VPWR VGND sg13cmos5l_fill_2
Xu_dll_u_control__2307_ u_dll_u_control__2307_/Q u_dll_u_control__2308_/CLK u_dll_u_control__2307_/D
+ u_dll_u_control__1967_/Y VPWR VGND sg13cmos5l_dfrbpq_1
Xu_dll_u_control__2238_ u_dll_u_control__2238_/Q u_dll_u_control__2317_/CLK u_dll_u_control__2238_/D
+ u_dll_u_control__2095_/Y VPWR VGND sg13cmos5l_dfrbpq_1
Xu_dll_u_div0__105_ u_dll_u_div0__105_/Q u_dll_u_div0__056_/A u_dll_u_div0__105_/D
+ u_dll_u_div0__105_/RESET_B VPWR VGND sg13cmos5l_dfrbpq_1
Xu_dll_u_control__2169_ u_dll_u_control__2169_/Q u_dll_u_control__2172_/CLK u_dll_u_control__2169_/D
+ u_dll_u_control__2026_/Y VPWR VGND sg13cmos5l_dfrbpq_1
Xu_dll_u_ring_dstage\[1\].id_core_trim_reset_inv_u_inv u_dll_u_ring_dstage\[1\].id_core_trim_reset_inv_u_inv/Y
+ u_dll_u_ring_trim_reset_buffers\[0\].u_buffer_u_buf/X VPWR VGND sg13cmos5l_inv_2
Xu_dll_u_ring_dstage\[9\].id_core_trim_sync\[1\].applied_u_ff u_dll_u_ring_dstage\[9\].id_core_long_gate_u_nand/B
+ u_dll_u_ring_dstage\[9\].id_core_delayinv1_u_inv/Y u_dll_u_ring_dstage\[9\].id_core_trim_sync\[1\].meta_u_ff/Q
+ u_dll_u_ring_dstage\[9\].id_core_trim_reset_inv_u_inv/Y VPWR VGND sg13cmos5l_dfrbpq_1
XFILLER_19_212 VPWR VGND sg13cmos5l_fill_2
XFILLER_42_292 VPWR VGND sg13cmos5l_decap_8
XFILLER_8_10 VPWR VGND sg13cmos5l_decap_4
Xu_dll_u_control__1540_ u_dll_u_control__1728_/A u_dll_u_control__1789_/B u_dll_u_control__2225_/Q
+ u_dll_u_control__1539_/Y VPWR VGND sg13cmos5l_a21o_1
XFILLER_6_193 VPWR VGND sg13cmos5l_fill_2
Xu_dll_u_control__1471_ u_dll_u_control__1472_/C u_dll_u_control__2165_/Q u_dll_u_control__1507_/B
+ VPWR VGND sg13cmos5l_nor2_1
XFILLER_40_229 VPWR VGND sg13cmos5l_decap_4
Xu_dll_u_control__2023_ u_dll_u_control__2023_/Y u_dll_u_control__2023_/A VPWR VGND
+ sg13cmos5l_inv_1
Xu_dll_u_control__1669_ u_dll_u_control__1669_/Y u_dll_u_control__1673_/A u_dll_u_control__1669_/B
+ u_dll_u_control__1673_/C VPWR VGND sg13cmos5l_nor3_1
Xu_dll_u_control__1738_ u_dll_u_control__2209_/D u_dll_u_control__1722_/Y u_dll_u_control__1723_/X
+ u_dll_u_control__1737_/Y VPWR VGND sg13cmos5l_a21oi_1
XFILLER_0_336 VPWR VGND sg13cmos5l_fill_2
Xu_dll_u_control__1807_ u_dll_u_control__1809_/B u_dll_u_control__1808_/A u_dll_u_control__1808_/B
+ VPWR VGND sg13cmos5l_and2_1
XFILLER_33_95 VPWR VGND sg13cmos5l_fill_1
XFILLER_33_51 VPWR VGND sg13cmos5l_fill_2
Xu_dll_u_control_fanout52 u_dll_u_control__1183_/A u_dll_u_control__2280_/Q VPWR VGND
+ sg13cmos5l_buf_1
Xu_dll_u_control_fanout96 u_dll_u_control_fanout96/X u_dll__20_/Y VPWR VGND sg13cmos5l_buf_1
Xu_dll_u_control_fanout85 u_dll_u_control__2090_/A u_dll_u_control_fanout96/X VPWR
+ VGND sg13cmos5l_buf_1
Xu_dll_u_control_fanout41 u_dll_u_control__1809_/A u_dll_u_control__1092_/Y VPWR VGND
+ sg13cmos5l_buf_1
Xu_dll_u_control_fanout30 u_dll_u_control__1382_/A u_dll_u_control_fanout32/X VPWR
+ VGND sg13cmos5l_buf_1
Xu_dll_u_control_fanout63 u_dll_u_control__2064_/A u_dll_u_control__2063_/A VPWR VGND
+ sg13cmos5l_buf_1
Xu_dll_u_control_fanout74 u_dll_u_control__2050_/A u_dll_u_control__2094_/A VPWR VGND
+ sg13cmos5l_buf_1
XFILLER_47_384 VPWR VGND sg13cmos5l_decap_8
Xu_dll_u_ring_dstage\[10\].id_core_long_gate_u_nand u_dll_u_ring_dstage\[10\].id_core_long_gate_u_nand/Y
+ u_dll_u_ring_dstage\[10\].id_core_long_gate_u_nand/A u_dll_u_ring_dstage\[10\].id_core_long_gate_u_nand/B
+ VPWR VGND sg13cmos5l_nand2_2
Xu_dll_u_control__1523_ u_dll_u_control__1523_/Y u_dll_u_control__2233_/Q u_dll_u_control__1523_/B
+ VPWR VGND sg13cmos5l_nor2_1
Xu_dll_u_control__1454_ u_dll_u_control__2171_/D u_dll_u_control__1456_/A u_dll_u_control__1454_/B
+ u_dll_u_control__1454_/C VPWR VGND sg13cmos5l_nor3_1
Xu_dll_u_control__1385_ u_dll_u_control__1385_/X u_dll_u_control__1899_/A u_dll_u_control__1385_/B
+ VPWR VGND sg13cmos5l_or2_1
Xu_dll_u_control__2006_ u_dll_u_control__2006_/Y u_dll_u_control__2082_/A VPWR VGND
+ sg13cmos5l_inv_1
Xu_dll_u_ring_dstage\[4\].id_core_delaymux1_u_sel u_dll_u_ring_dstage\[4\].id_core_delaymux1_u_a0/B
+ u_dll_u_ring_dstage\[4\].id_core_delaymux1_u_a1/B VPWR VGND sg13cmos5l_inv_1
Xu_dll_u_control_rebuffer130 u_dll_u_control__1325_/A2 u_dll_u_control__1923_/C VPWR
+ VGND sg13cmos5l_buf_1
Xu_dll_u_ring_dstage\[6\].id_core_slow_isolation_u_buf u_dll_u_ring_dstage\[6\].id_core_delaymux1_u_a1/A
+ u_dll_u_ring_dstage\[5\].id_core_reset_gate_u_aoi/Y VPWR VGND sg13cmos5l_buf_2
Xheichips26_multimode_dll_small_116 uio_out[7] VPWR VGND sg13cmos5l_tielo
Xheichips26_multimode_dll_small_105 uio_oe[4] VPWR VGND sg13cmos5l_tielo
XFILLER_44_61 VPWR VGND sg13cmos5l_fill_2
Xu_dll_u_ring_dstage\[4\].id_core_short_decode_u_and u_dll_u_ring_dstage\[4\].id_core_short_gate_u_nand/B
+ u_dll_u_ring_dstage\[4\].id_core_delaymux1_u_a1/B u_dll_u_ring_dstage\[4\].id_core_short_decode_u_and/B
+ VPWR VGND sg13cmos5l_and2_2
Xu_dll_u_control__1170_ u_dll_u_control__1172_/A u_dll_u_control__2286_/Q u_dll_u_control__1170_/B
+ VPWR VGND sg13cmos5l_nor2_1
XFILLER_45_107 VPWR VGND sg13cmos5l_decap_4
Xu_dll_u_control__1437_ u_dll_u_control__1438_/C u_dll_u_control__1451_/B u_dll_u_control__1436_/X
+ u_dll_u_control__2176_/Q VPWR VGND sg13cmos5l_a21oi_1
Xu_dll_u_control__1506_ u_dll_u_control__1508_/B u_dll_u_control__2181_/Q u_dll_u_control__1506_/B
+ VPWR VGND sg13cmos5l_nor2_1
XFILLER_41_379 VPWR VGND sg13cmos5l_fill_1
Xu_dll_u_control__1299_ u_dll_u_control__1299_/Y u_dll_u_control__1299_/A u_dll_u_control__1926_/A
+ u_dll_u_control__2322_/Q VPWR VGND sg13cmos5l_nor3_1
Xu_dll_u_control__1368_ u_dll_u_control__1369_/C u_dll_u_control__2198_/Q u_dll_u_control__1371_/A
+ VPWR VGND sg13cmos5l_nor2b_1
Xu_dll_u_div1__051_ u_dll_u_div1__062_/A u_dll_u_div1__108_/Q VPWR VGND sg13cmos5l_inv_1
XFILLER_32_313 VPWR VGND sg13cmos5l_fill_2
XFILLER_17_343 VPWR VGND sg13cmos5l_fill_2
XFILLER_32_379 VPWR VGND sg13cmos5l_fill_1
XFILLER_27_118 VPWR VGND sg13cmos5l_fill_2
Xu_dll_u_control__1153_ u_dll_u_control__1153_/Y u_dll_u_control__1131_/A u_dll_u_control__1183_/B
+ u_dll_u_control__1133_/Y VPWR VGND sg13cmos5l_o21ai_1
Xu_dll_u_control__1222_ u_dll_u_control__1224_/B u_dll_u_control__1137_/Y u_dll_u_control__1228_/A
+ u_dll_u_control__1246_/B VPWR VGND sg13cmos5l_a21oi_1
Xu_dll_u_control__2271_ u_dll_u_control__2271_/Q u_dll_u_control__2271_/CLK u_dll_u_control__2271_/D
+ u_dll_u_control__1690_/D VPWR VGND sg13cmos5l_dfrbpq_1
Xu_dll_u_control__1084_ u_dll_u_control__1300_/A u_dll_u_control__2322_/Q VPWR VGND
+ sg13cmos5l_inv_1
Xu_dll_u_control__1986_ u_dll_u_control__1986_/Y u_dll_u_control__2127_/A VPWR VGND
+ sg13cmos5l_inv_1
Xu_dll_u_ring_dstage\[4\].id_core_secondary_inv_u_inv u_dll_u_ring_dstage\[4\].id_core_short_decode_u_and/B
+ u_dll_u_ring_dstage\[4\].id_core_long_gate_u_nand/B VPWR VGND sg13cmos5l_inv_1
Xclkbuf_5_31__f_u_dll\_controller_ref_clk u_dll_u_control__2279_/CLK clkbuf_4_15_0_u_dll\_controller_ref_clk/X
+ VPWR VGND sg13cmos5l_buf_8
Xu_dll_u_ring_dstage\[4\].id_core_reset_inv_u_inv u_dll_u_ring_dstage\[4\].id_core_reset_inv_u_inv/Y
+ u_dll_u_ring_dstage\[4\].id_const0_u_lo/L_LO VPWR VGND sg13cmos5l_inv_1
XFILLER_49_254 VPWR VGND sg13cmos5l_fill_2
XFILLER_49_210 VPWR VGND sg13cmos5l_fill_2
Xu_dll_u_div1__103_ u_dll_u_div1__103_/Q u_dll_u_div1__056_/A u_dll_u_div1__103_/D
+ u_dll_u_div1__105_/RESET_B VPWR VGND sg13cmos5l_dfrbpq_1
XFILLER_32_143 VPWR VGND sg13cmos5l_fill_2
XFILLER_32_198 VPWR VGND sg13cmos5l_decap_4
Xu_dll_u_control__1840_ u_dll_u_control__2256_/D u_dll_u_control__1840_/A u_dll_u_control__1848_/A
+ VPWR VGND sg13cmos5l_nor2b_1
Xu_dll_u_control__1771_ u_dll_u_control__2241_/D u_dll_u_control__1766_/Y u_dll_u_control__1776_/B
+ u_dll_u_control__1770_/Y VPWR VGND sg13cmos5l_a21oi_1
Xu_dll_u_control__2323_ u_dll_u_control__2323_/Q u_dll_u_control__2324_/CLK ui_in[3]
+ u_dll_u_control__1983_/Y VPWR VGND sg13cmos5l_dfrbpq_1
Xu_dll_u_control__2254_ u_dll_u_control__2254_/Q clkload5/A u_dll_u_control__2254_/D
+ u_dll_u_control__2111_/Y VPWR VGND sg13cmos5l_dfrbpq_1
Xu_dll_u_control_fanout7 u_dll_u_control__1673_/A u_dll_u_control__1665_/A VPWR VGND
+ sg13cmos5l_buf_1
Xu_dll_u_control__1136_ u_dll_u_control__1200_/A u_dll_u_control__1618_/A u_dll_u_control__1166_/B
+ VPWR VGND sg13cmos5l_nor2_1
Xu_dll_u_control__1205_ u_dll_u_control__1205_/Y u_dll_u_control__1140_/X u_dll_u_control__1228_/A
+ VPWR VGND sg13cmos5l_nand2b_1
Xu_dll_u_control__1067_ u_dll_u_control__1067_/Y u_dll_u_control__2270_/Q VPWR VGND
+ sg13cmos5l_inv_1
Xu_dll_u_control__2185_ u_dll_u_control__2185_/Q u_dll_u_control__2185_/CLK u_dll_u_control__2185_/D
+ u_dll_u_control__2042_/Y VPWR VGND sg13cmos5l_dfrbpq_1
Xu_dll_u_div0__052_ u_dll_u_div0__070_/A u_dll_u_div0__103_/Q VPWR VGND sg13cmos5l_inv_1
Xu_dll_u_control__1969_ u_dll_u_control__1969_/Y u_dll_u_control__2050_/A VPWR VGND
+ sg13cmos5l_inv_1
Xu_dll_u_ring_dstage\[3\].id_core_delaybuf1_u_buf u_dll_u_ring_dstage\[3\].id_core_delayinv1_u_inv/A
+ u_dll_u_ring_dstage\[3\].id_core_delaymux1_u_a1/A VPWR VGND sg13cmos5l_buf_1
Xu_dll_u_control__1823_ u_dll_u_control__1824_/B u_dll_u_control__2165_/Q u_dll_u_control__1919_/B
+ u_dll_u_control__1823_/C VPWR VGND sg13cmos5l_nand3_1
Xu_dll_u_control__1754_ u_dll_u_control__1754_/Y u_dll_u_control__1788_/A u_dll_u_control__1760_/B
+ u_dll_u_control__1750_/Y VPWR VGND sg13cmos5l_o21ai_1
Xu_dll_u_control__1685_ u_dll_u_control__2281_/D u_dll_u_control__1876_/A u_dll_u_control__1846_/B
+ VPWR VGND sg13cmos5l_nor2_1
XFILLER_43_205 VPWR VGND sg13cmos5l_fill_2
Xu_dll_u_control__2306_ u_dll_u_control__2306_/Q clkload0/A u_dll_u_control__2306_/D
+ u_dll_u_control__1966_/Y VPWR VGND sg13cmos5l_dfrbpq_1
Xu_dll_u_control__2237_ u_dll_u_control__2237_/Q u_dll_u_control__2312_/CLK u_dll_u_control__2237_/D
+ u_dll_u_control__2094_/Y VPWR VGND sg13cmos5l_dfrbpq_1
Xu_dll_u_control__1119_ u_dll_u_control__1120_/C u_dll_u_control__2135_/Q u_dll_u_control__2275_/Q
+ u_dll_u_control__1116_/Y u_dll_u_control__1117_/X u_dll_u_control__1112_/X VPWR
+ VGND sg13cmos5l_a221oi_1
Xu_dll_u_div0__104_ u_dll_u_div0__104_/Q u_dll_u_div0__056_/A u_dll_u_div0__104_/D
+ u_dll_u_div0__105_/RESET_B VPWR VGND sg13cmos5l_dfrbpq_1
Xu_dll_u_control__2099_ u_dll_u_control__2099_/Y u_dll_u_control__2099_/A VPWR VGND
+ sg13cmos5l_inv_1
Xu_dll_u_control__2168_ u_dll_u_control__2168_/Q u_dll_u_control__2172_/CLK u_dll_u_control__2168_/D
+ u_dll_u_control__2025_/Y VPWR VGND sg13cmos5l_dfrbpq_1
Xu_dll_u_ring_dstage\[4\].id_core_trim_sync\[1\].applied_u_ff u_dll_u_ring_dstage\[4\].id_core_long_gate_u_nand/B
+ u_dll_u_ring_dstage\[4\].id_core_delayinv1_u_inv/Y u_dll_u_ring_dstage\[4\].id_core_trim_sync\[1\].meta_u_ff/Q
+ u_dll_u_ring_dstage\[4\].id_core_trim_reset_inv_u_inv/Y VPWR VGND sg13cmos5l_dfrbpq_1
Xu_dll_u_div1_u_parity_mux_u_sel u_dll_u_div1_u_parity_mux_u_a0/B u_dll_u_div1__106_/Q
+ VPWR VGND sg13cmos5l_inv_1
XFILLER_30_400 VPWR VGND sg13cmos5l_decap_4
Xu_dll_u_control__1470_ u_dll_u_control__1470_/X u_dll_u_control__1741_/A u_dll_u_control__1707_/C
+ u_dll_u_control__1913_/A VPWR VGND sg13cmos5l_a21o_1
Xu_dll_u_control__2022_ u_dll_u_control__2022_/Y u_dll_u_control__2050_/A VPWR VGND
+ sg13cmos5l_inv_1
Xu_dll_u_control__1806_ u_dll_u_control__1808_/B u_dll_u_control__2162_/Q u_dll_u_control__2322_/Q
+ VPWR VGND sg13cmos5l_xor2_1
Xu_dll_u_control__1668_ u_dll_u_control__2135_/D u_dll_u_control__2135_/Q u_dll_u_control__1673_/A
+ u_dll_u_control__1667_/Y VPWR VGND sg13cmos5l_a21o_1
Xu_dll_u_control__1599_ u_dll_u_control__1599_/Y u_dll_u_control__1599_/A u_dll_u_control__1599_/B
+ u_dll_u_control__1623_/A VPWR VGND sg13cmos5l_nand3_1
Xu_dll_u_control__1737_ u_dll_u_control__1737_/Y u_dll_u_control__1737_/A u_dll_u_control__1737_/B
+ VPWR VGND sg13cmos5l_nor2_1
Xu_dll_u_control_fanout42 u_dll_u_control__1742_/A u_dll_u_control__1299_/A VPWR VGND
+ sg13cmos5l_buf_1
XFILLER_33_74 VPWR VGND sg13cmos5l_decap_4
Xu_dll_u_control_fanout20 u_dll_u_control__1456_/A u_dll_u_control__1418_/Y VPWR VGND
+ sg13cmos5l_buf_4
Xu_dll_u_control_fanout31 u_dll_u_control__1371_/A u_dll_u_control_fanout32/X VPWR
+ VGND sg13cmos5l_buf_1
Xu_dll_u_control_fanout86 u_dll_u_control__2099_/A u_dll_u_control_fanout96/X VPWR
+ VGND sg13cmos5l_buf_1
XFILLER_39_319 VPWR VGND sg13cmos5l_decap_8
Xu_dll_u_control_fanout53 u_dll_u_control__1618_/B u_dll_u_control__2245_/Q VPWR VGND
+ sg13cmos5l_buf_1
XFILLER_3_186 VPWR VGND sg13cmos5l_fill_1
XFILLER_3_142 VPWR VGND sg13cmos5l_fill_2
Xu_dll_u_control_fanout64 u_dll_u_control__2063_/A u_dll_u_control_fanout78/X VPWR
+ VGND sg13cmos5l_buf_1
Xu_dll_u_control_fanout75 u_dll_u_control__2127_/A u_dll_u_control__2094_/A VPWR VGND
+ sg13cmos5l_buf_1
XFILLER_15_271 VPWR VGND sg13cmos5l_decap_8
XFILLER_22_219 VPWR VGND sg13cmos5l_decap_8
XFILLER_38_352 VPWR VGND sg13cmos5l_decap_4
Xu_dll_u_control__1522_ u_dll_u_control__1522_/X u_dll_u_control__2232_/Q u_dll_u_control__2233_/Q
+ VPWR VGND sg13cmos5l_or2_1
Xu_dll_u_control__1453_ u_dll_u_control__1454_/C u_dll_u_control__2171_/Q u_dll_u_control__1452_/Y
+ VPWR VGND sg13cmos5l_nor2b_1
Xu_dll_u_control__2005_ u_dll_u_control__2005_/Y u_dll_u_control__2083_/A VPWR VGND
+ sg13cmos5l_inv_1
Xu_dll_u_control__1384_ u_dll_u_control__2194_/D u_dll_u_control__1384_/A u_dll_u_control__1384_/B
+ u_dll_u_control__1384_/C VPWR VGND sg13cmos5l_nor3_1
Xu_dll_u_ring_dstage\[4\].id_const0_u_lo u_dll_u_ring_dstage\[4\].id_const0_u_lo/L_LO
+ VPWR VGND sg13cmos5l_tielo
Xu_dll_u_control_rebuffer131 u_dll_u_control__1458_/A u_dll_u_control__1418_/Y VPWR
+ VGND sg13cmos5l_buf_1
Xheichips26_multimode_dll_small_117 uo_out[3] VPWR VGND sg13cmos5l_tielo
Xheichips26_multimode_dll_small_106 uio_oe[5] VPWR VGND sg13cmos5l_tielo
XFILLER_44_399 VPWR VGND sg13cmos5l_decap_4
XFILLER_44_73 VPWR VGND sg13cmos5l_fill_1
Xu_dll_u_ring_dstage\[1\].id_core_delaymux1_u_merge u_dll_u_ring_dstage\[1\].id_core_long_gate_u_nand/A
+ u_dll_u_ring_dstage\[1\].id_core_delaymux1_u_a0/Y u_dll_u_ring_dstage\[1\].id_core_delaymux1_u_a1/Y
+ VPWR VGND sg13cmos5l_nand2_2
XFILLER_10_4 VPWR VGND sg13cmos5l_decap_4
XFILLER_35_377 VPWR VGND sg13cmos5l_fill_2
XFILLER_35_300 VPWR VGND sg13cmos5l_fill_2
XFILLER_38_160 VPWR VGND sg13cmos5l_fill_2
Xu_dll_u_control__1436_ u_dll_u_control__1436_/X u_dll_u_control__2179_/Q u_dll_u_control__2175_/Q
+ u_dll_u_control__2174_/Q u_dll_u_control__2173_/Q VPWR VGND sg13cmos5l_and4_1
Xu_dll_u_control__1505_ u_dll_u_control__2154_/D u_dll_u_control__1508_/A u_dll_u_control__1505_/B
+ u_dll_u_control__1505_/C VPWR VGND sg13cmos5l_nor3_1
Xu_dll_u_control__1298_ u_dll_u_control__1537_/B u_dll_u_control__1742_/A u_dll_u_control__1926_/A
+ VPWR VGND sg13cmos5l_nor2_1
Xu_dll_u_control__1367_ u_dll_u_control__1369_/B u_dll_u_control__1362_/B u_dll_u_control__1366_/X
+ u_dll_u_control__1371_/A VPWR VGND sg13cmos5l_a21oi_1
XFILLER_5_226 VPWR VGND sg13cmos5l_fill_1
Xu_dll_u_div1__050_ u_dll_u_div1__050_/Y u_dll_u_div1__109_/Q VPWR VGND sg13cmos5l_inv_1
XFILLER_39_62 VPWR VGND sg13cmos5l_fill_1
XFILLER_44_196 VPWR VGND sg13cmos5l_decap_4
XFILLER_17_399 VPWR VGND sg13cmos5l_decap_4
Xclkbuf_0_u_dll\_controller_ring_clk clkbuf_0_u_dll\_controller_ring_clk/X u_dll_u_controller_buffer_u_buf/X
+ VPWR VGND sg13cmos5l_buf_8
XFILLER_4_281 VPWR VGND sg13cmos5l_decap_8
Xu_dll_u_control__1221_ u_dll_u_control__1224_/A u_dll_u_control__1219_/X u_dll_u_control__1220_/Y
+ u_dll_u_control__1247_/A VPWR VGND sg13cmos5l_o21ai_1
Xu_dll_u_control__2270_ u_dll_u_control__2270_/Q clkload1/A u_dll_u_control__2270_/D
+ u_dll_u_control__2127_/Y VPWR VGND sg13cmos5l_dfrbpq_1
Xu_dll_u_control__1152_ u_dll_u_control__1160_/B u_dll_u_control__1150_/Y u_dll_u_control__2142_/Q
+ u_dll_u_control__1152_/S VPWR VGND sg13cmos5l_mux2_1
Xu_dll_u_control__1083_ u_dll_u_control__1083_/Y u_dll_u_control__2150_/Q VPWR VGND
+ sg13cmos5l_inv_1
Xu_dll_u_control__1985_ u_dll_u_control__1985_/Y u_dll_u_control__2090_/A VPWR VGND
+ sg13cmos5l_inv_1
Xu_dll_u_control__1419_ u_dll_u_control__1420_/B u_dll_u_control__1456_/A VPWR VGND
+ sg13cmos5l_inv_4
XFILLER_14_347 VPWR VGND sg13cmos5l_decap_8
XFILLER_22_380 VPWR VGND sg13cmos5l_decap_8
Xu_dll_u_div1__102_ u_dll_u_div1__102_/Q u_dll_u_div1__056_/A u_dll_u_div1__102_/D
+ u_dll_u_div1__105_/RESET_B VPWR VGND sg13cmos5l_dfrbpq_1
XFILLER_32_133 VPWR VGND sg13cmos5l_fill_2
Xu_dll_u_ring_dstage\[2\].id_core_trim_reset_inv_u_inv u_dll_u_ring_dstage\[2\].id_core_trim_reset_inv_u_inv/Y
+ u_dll_u_ring_trim_reset_buffers\[0\].u_buffer_u_buf/X VPWR VGND sg13cmos5l_inv_2
XFILLER_49_0 VPWR VGND sg13cmos5l_decap_4
Xu_dll_u_control__1770_ u_dll_u_control__1770_/Y u_dll_u_control__1766_/Y u_dll_u_control__1768_/Y
+ u_dll_u_control__1679_/A VPWR VGND sg13cmos5l_o21ai_1
Xu_dll_u_control__1204_ u_dll_u_control__1204_/X u_dll_u_control__1199_/Y u_dll_u_control__1202_/Y
+ u_dll_u_control__1181_/X VPWR VGND sg13cmos5l_a21o_1
Xu_dll_u_control__2322_ u_dll_u_control__2322_/Q u_dll_u_control__2322_/CLK ui_in[2]
+ u_dll_u_control__1982_/Y VPWR VGND sg13cmos5l_dfrbpq_1
Xu_dll_u_control__2253_ u_dll_u_control__2253_/Q u_dll_u_control__2266_/CLK u_dll_u_control__2253_/D
+ u_dll_u_control__2110_/Y VPWR VGND sg13cmos5l_dfrbpq_1
Xu_dll_u_control__2184_ u_dll_u_control__2184_/Q u_dll_u_control__2185_/CLK u_dll_u_control__2184_/D
+ u_dll_u_control__2041_/Y VPWR VGND sg13cmos5l_dfrbpq_1
Xu_dll_u_control__1135_ u_dll_u_control__1166_/B u_dll_u_control__2144_/Q u_dll_u_control__2143_/Q
+ u_dll_u_control__1552_/B u_dll_u_control__1151_/B VPWR VGND sg13cmos5l_nand4_1
Xu_dll_u_control_fanout8 u_dll_u_control__1661_/A u_dll_u_control__1665_/A VPWR VGND
+ sg13cmos5l_buf_1
Xu_dll_u_div0__051_ u_dll_u_div0__062_/A u_dll_u_div0__108_/Q VPWR VGND sg13cmos5l_inv_1
Xu_dll_u_ring_dstage\[9\].id_const0_u_lo u_dll_u_ring_dstage\[9\].id_const0_u_lo/L_LO
+ VPWR VGND sg13cmos5l_tielo
Xu_dll_u_control__1968_ u_dll_u_control__1968_/Y u_dll_u_control__2063_/A VPWR VGND
+ sg13cmos5l_inv_1
Xu_dll_u_control__1899_ u_dll_u_control__2290_/D u_dll_u_control__1899_/A u_dll_u_control__1899_/B
+ VPWR VGND sg13cmos5l_nor2_1
Xu_dll_u_ring_dstage\[5\].id_core_delaymux1_u_a0 u_dll_u_ring_dstage\[5\].id_core_delaymux1_u_a0/Y
+ u_dll_u_ring_dstage\[5\].id_core_delaymux1_u_a0/A u_dll_u_ring_dstage\[5\].id_core_delaymux1_u_a0/B
+ VPWR VGND sg13cmos5l_nand2_2
XFILLER_6_343 VPWR VGND sg13cmos5l_fill_1
Xu_dll_u_control__1753_ u_dll_u_control__1760_/B u_dll_u_control__1742_/A u_dll_u_control__1724_/B
+ u_dll_u_control__1752_/Y VPWR VGND sg13cmos5l_a21oi_1
Xu_dll_u_control__1822_ u_dll_u_control__2237_/D u_dll_u_control__2165_/Q u_dll_u_control__1913_/A
+ u_dll_u_control__1823_/C VPWR VGND sg13cmos5l_nor3_1
Xu_dll_u_control__1684_ u_dll_u_control__2282_/D u_dll_u_control__1876_/A u_dll_u_control__1684_/B
+ VPWR VGND sg13cmos5l_nor2_1
Xu_dll_u_control__2167_ u_dll_u_control__2167_/Q u_dll_u_control__2172_/CLK u_dll_u_control__2167_/D
+ u_dll_u_control__2024_/Y VPWR VGND sg13cmos5l_dfrbpq_1
Xu_dll_u_control__2305_ u_dll_u_control__2305_/Q u_dll_u_control__2308_/CLK u_dll_u_control__2305_/D
+ u_dll_u_control__1965_/Y VPWR VGND sg13cmos5l_dfrbpq_1
Xu_dll_u_control__2236_ u_dll_u_control__2236_/Q u_dll_u_control__2312_/CLK u_dll_u_control__2236_/D
+ u_dll_u_control__2093_/Y VPWR VGND sg13cmos5l_dfrbpq_1
Xu_dll_u_control__1118_ u_dll_u_control__1875_/A u_dll_u_control__1116_/Y u_dll_u_control__1117_/X
+ u_dll_u_control__1112_/X VPWR VGND sg13cmos5l_a21oi_1
Xu_dll_u_control__2098_ u_dll_u_control__2098_/Y u_dll_u_control__2099_/A VPWR VGND
+ sg13cmos5l_inv_1
Xu_dll_u_div0__103_ u_dll_u_div0__103_/Q u_dll_u_div0__056_/A u_dll_u_div0__103_/D
+ u_dll_u_div0__105_/RESET_B VPWR VGND sg13cmos5l_dfrbpq_1
XFILLER_11_147 VPWR VGND sg13cmos5l_fill_1
XFILLER_47_84 VPWR VGND sg13cmos5l_fill_2
XFILLER_47_62 VPWR VGND sg13cmos5l_fill_2
XFILLER_34_217 VPWR VGND sg13cmos5l_fill_1
XFILLER_19_214 VPWR VGND sg13cmos5l_fill_1
Xclkbuf_2_2_0_u_dll\_controller_ref_clk clkbuf_4_9_0_u_dll\_controller_ref_clk/A clkbuf_2_3_0_u_dll\_controller_ref_clk/A
+ VPWR VGND sg13cmos5l_buf_8
Xu_dll_u_ring_dstage\[4\].id_core_delaymux1_u_merge u_dll_u_ring_dstage\[4\].id_core_long_gate_u_nand/A
+ u_dll_u_ring_dstage\[4\].id_core_delaymux1_u_a0/Y u_dll_u_ring_dstage\[4\].id_core_delaymux1_u_a1/Y
+ VPWR VGND sg13cmos5l_nand2_2
Xu_dll_u_ring_dstage\[7\].id_core_slow_isolation_u_buf u_dll_u_ring_dstage\[7\].id_core_delaymux1_u_a1/A
+ u_dll_u_ring_dstage\[6\].id_core_reset_gate_u_aoi/Y VPWR VGND sg13cmos5l_buf_2
Xu_dll_u_control__2021_ u_dll_u_control__2021_/Y u_dll_u_control__2050_/A VPWR VGND
+ sg13cmos5l_inv_1
XFILLER_25_228 VPWR VGND sg13cmos5l_fill_1
Xu_dll_u_control__1736_ u_dll_u_control__1737_/B u_dll_u_control__2152_/Q u_dll_u_control__1561_/Y
+ u_dll_u_control__1735_/Y VPWR VGND sg13cmos5l_a21oi_1
Xu_dll_u_control__1805_ u_dll_u_control__1808_/A u_dll_u_control__2161_/Q u_dll_u_control__1085_/Y
+ u_dll_u_control__1804_/C VPWR VGND sg13cmos5l_a21oi_1
Xu_dll_u_control__1667_ u_dll_u_control__1667_/Y u_dll_u_control__1673_/A u_dll_u_control__1667_/B
+ u_dll_u_control__1673_/C VPWR VGND sg13cmos5l_nor3_1
Xu_dll_u_control__1598_ u_dll_u_control__1623_/A u_dll_u_control__2143_/Q u_dll_u_control__1618_/B
+ VPWR VGND sg13cmos5l_xor2_1
Xu_dll_u_control__2219_ u_dll_u_control__2219_/Q u_dll_u_control__2223_/CLK u_dll_u_control__2219_/D
+ u_dll_u_control__2076_/Y VPWR VGND sg13cmos5l_dfrbpq_1
Xu_dll_u_control_fanout10 u_dll_u_control__1665_/A u_dll_u_control__1615_/X VPWR VGND
+ sg13cmos5l_buf_1
Xu_dll_u_control_fanout54 u_dll_u_control__1629_/B u_dll_u_control__2245_/Q VPWR VGND
+ sg13cmos5l_buf_1
Xu_dll_u_control_fanout43 u_dll_u_control__1299_/A u_dll_u_control__1925_/A VPWR VGND
+ sg13cmos5l_buf_1
Xu_dll_u_control_fanout65 u_dll_u_control__2035_/A u_dll_u_control_fanout69/X VPWR
+ VGND sg13cmos5l_buf_1
XFILLER_3_110 VPWR VGND sg13cmos5l_fill_1
Xu_dll_u_control_fanout32 u_dll_u_control_fanout32/X u_dll_u_control__1386_/A VPWR
+ VGND sg13cmos5l_buf_1
Xu_dll_u_control_fanout21 u_dll_u_control__1386_/C u_dll_u_control__1385_/X VPWR VGND
+ sg13cmos5l_buf_1
Xu_dll_u_control_fanout76 u_dll_u_control__2093_/A u_dll_u_control__2094_/A VPWR VGND
+ sg13cmos5l_buf_1
Xu_dll_u_control_fanout87 u_dll_u_control__2095_/A u_dll_u_control_fanout96/X VPWR
+ VGND sg13cmos5l_buf_1
Xu_dll_u_ring_dstage\[9\].id_core_short_decode_u_and u_dll_u_ring_dstage\[9\].id_core_short_gate_u_nand/B
+ u_dll_u_ring_dstage\[9\].id_core_delaymux1_u_a1/B u_dll_u_ring_dstage\[9\].id_core_short_decode_u_and/B
+ VPWR VGND sg13cmos5l_and2_2
XFILLER_15_261 VPWR VGND sg13cmos5l_fill_1
Xu_dll_u_control__1521_ u_dll_u_control__1523_/B u_dll_u_control__1526_/A u_dll_u_control__2231_/Q
+ u_dll_u_control__1520_/Y VPWR VGND sg13cmos5l_a21oi_1
Xu_dll_u_control__1383_ u_dll_u_control__1384_/C u_dll_u_control__2194_/Q u_dll_u_control__1382_/A
+ VPWR VGND sg13cmos5l_nor2b_1
Xu_dll_u_control__1452_ u_dll_u_control__1452_/Y u_dll_u_control__1424_/B u_dll_u_control__1462_/A
+ VPWR VGND sg13cmos5l_nand2b_1
Xu_dll_u_control__2004_ u_dll_u_control__2004_/Y u_dll_u_control__2083_/A VPWR VGND
+ sg13cmos5l_inv_1
Xu_dll_u_control_rebuffer132 u_dll_u_control__1319_/B u_dll_u_control__1385_/B VPWR
+ VGND sg13cmos5l_buf_1
Xu_dll_u_control__1719_ u_dll_u_control__1719_/Y u_dll_u_control__2220_/Q u_dll_u_control__1719_/B
+ VPWR VGND sg13cmos5l_nand2_1
XFILLER_29_320 VPWR VGND sg13cmos5l_decap_4
Xheichips26_multimode_dll_small_118 uo_out[4] VPWR VGND sg13cmos5l_tielo
Xu_dll_u_ring_dstage\[1\].id_core_merge_gate_u_nand u_dll_u_ring_dstage\[1\].id_core_reset_gate_u_aoi/B1
+ u_dll_u_ring_dstage\[1\].id_core_short_gate_u_nand/Y u_dll_u_ring_dstage\[1\].id_core_long_gate_u_nand/Y
+ u_dll_u_ring_dstage\[1\].id_core_reset_inv_u_inv/Y VPWR VGND sg13cmos5l_nand3_1
Xheichips26_multimode_dll_small_107 uio_oe[6] VPWR VGND sg13cmos5l_tielo
XFILLER_44_378 VPWR VGND sg13cmos5l_decap_8
XFILLER_29_331 VPWR VGND sg13cmos5l_fill_1
XFILLER_5_13 VPWR VGND sg13cmos5l_fill_1
XFILLER_47_172 VPWR VGND sg13cmos5l_fill_2
XFILLER_39_117 VPWR VGND sg13cmos5l_fill_1
Xclkbuf_5_10__f_u_dll\_controller_ref_clk u_dll_u_control__2324_/CLK clkbuf_4_5_0_u_dll\_controller_ref_clk/X
+ VPWR VGND sg13cmos5l_buf_8
XFILLER_38_172 VPWR VGND sg13cmos5l_fill_2
Xu_dll_u_control__1435_ u_dll_u_control__2177_/D u_dll_u_control__1435_/A u_dll_u_control__1435_/B
+ VPWR VGND sg13cmos5l_nor2_1
Xu_dll_u_control__1366_ u_dll_u_control__1366_/X u_dll_u_control__2198_/Q u_dll_u_control__1366_/B
+ VPWR VGND sg13cmos5l_or2_1
Xu_dll_u_control__1504_ u_dll_u_control__1505_/C u_dll_u_control__2154_/Q u_dll_u_control__1507_/B
+ VPWR VGND sg13cmos5l_nor2_1
XFILLER_41_348 VPWR VGND sg13cmos5l_decap_4
Xu_dll_u_control__1297_ u_dll_u_control__1741_/A u_dll_u_control__1469_/A u_dll_u_control__1297_/B
+ VPWR VGND sg13cmos5l_nor2_1
XFILLER_5_249 VPWR VGND sg13cmos5l_decap_8
XFILLER_44_131 VPWR VGND sg13cmos5l_fill_1
XFILLER_32_315 VPWR VGND sg13cmos5l_fill_1
XFILLER_32_304 VPWR VGND sg13cmos5l_fill_1
Xu_dll_u_ring_dstage\[8\].id_core_trim_sync\[0\].applied_u_ff u_dll_u_ring_dstage\[8\].id_core_delaymux1_u_a1/B
+ u_dll_u_ring_dstage\[8\].id_core_delayinv1_u_inv/Y u_dll_u_ring_dstage\[8\].id_core_trim_sync\[0\].meta_u_ff/Q
+ u_dll_u_ring_dstage\[8\].id_core_trim_reset_inv_u_inv/Y VPWR VGND sg13cmos5l_dfrbpq_1
XFILLER_4_260 VPWR VGND sg13cmos5l_decap_8
Xu_dll_u_control__1220_ u_dll_u_control__1220_/Y u_dll_u_control__2285_/Q u_dll_u_control__1227_/B
+ u_dll_u_control__2286_/Q VPWR VGND sg13cmos5l_a21oi_1
Xu_dll_u_control__1151_ u_dll_u_control__1191_/A u_dll_u_control__1552_/B u_dll_u_control__1151_/B
+ VPWR VGND sg13cmos5l_xnor2_1
Xu_dll_u_control__1082_ u_dll_u_control__1683_/A u_dll_u_control__2166_/Q VPWR VGND
+ sg13cmos5l_inv_1
Xu_dll_u_ring_dstage\[1\].id_core_reset_gate_u_aoi u_dll_u_ring_dstage\[1\].id_core_reset_gate_u_aoi/Y
+ u_dll_u_ring_dstage\[0\].id_core_reset_gate_u_aoi/Y u_dll_u_ring_dstage\[1\].id_core_reset_gate_u_aoi/A2
+ u_dll_u_ring_dstage\[1\].id_core_reset_gate_u_aoi/B1 VPWR VGND sg13cmos5l_a21oi_2
Xu_dll_u_control__1984_ u_dll_u_control__1984_/Y u_dll_u_control__2082_/A VPWR VGND
+ sg13cmos5l_inv_1
XFILLER_41_101 VPWR VGND sg13cmos5l_decap_4
Xu_dll_u_control__1349_ u_dll_u_control__2202_/D u_dll_u_control__1384_/A u_dll_u_control__1349_/B
+ u_dll_u_control__1349_/C VPWR VGND sg13cmos5l_nor3_1
Xu_dll_u_control__1418_ u_dll_u_control__1418_/Y u_dll_u_control__1418_/A u_dll_u_control__1898_/A
+ VPWR VGND sg13cmos5l_nand2_2
XFILLER_25_10 VPWR VGND sg13cmos5l_decap_4
Xclkbuf_4_12_0_u_dll\_controller_ref_clk clkbuf_4_12_0_u_dll\_controller_ref_clk/X
+ clkbuf_2_3_0_u_dll\_controller_ref_clk/X VPWR VGND sg13cmos5l_buf_8
Xu_dll_u_div1__101_ u_dll_u_div1__101_/Q u_dll_u_div1__056_/A u_dll_u_div1__101_/D
+ u_dll_u_div1__105_/RESET_B VPWR VGND sg13cmos5l_dfrbpq_1
XFILLER_49_234 VPWR VGND sg13cmos5l_fill_1
XFILLER_17_142 VPWR VGND sg13cmos5l_fill_1
XFILLER_32_145 VPWR VGND sg13cmos5l_fill_1
Xclkbuf_4_10__f_u_dll\_controller_ring_clk u_dll_u_control__2179_/CLK clkbuf_3_5_0_u_dll\_controller_ring_clk/X
+ VPWR VGND sg13cmos5l_buf_8
Xu_dll_u_ring_dstage\[7\].id_core_delaymux1_u_merge u_dll_u_ring_dstage\[7\].id_core_long_gate_u_nand/A
+ u_dll_u_ring_dstage\[7\].id_core_delaymux1_u_a0/Y u_dll_u_ring_dstage\[7\].id_core_delaymux1_u_a1/Y
+ VPWR VGND sg13cmos5l_nand2_2
Xu_dll_u_control__2321_ u_dll_u_control__2321_/Q u_dll_u_control__2324_/CLK ui_in[1]
+ u_dll_u_control__1981_/Y VPWR VGND sg13cmos5l_dfrbpq_1
Xu_dll_u_control__1134_ u_dll_u_control__1147_/B u_dll_u_control__2143_/Q u_dll_u_control__1552_/B
+ u_dll_u_control__1151_/B VPWR VGND sg13cmos5l_nand3_1
Xu_dll_u_control__1203_ u_dll_u_control__1245_/S u_dll_u_control__1199_/Y u_dll_u_control__1202_/Y
+ u_dll_u_control__1181_/X VPWR VGND sg13cmos5l_a21oi_1
Xu_dll_u_control__2252_ u_dll_u_control__2252_/Q clkload5/A u_dll_u_control__2252_/D
+ u_dll_u_control__2109_/Y VPWR VGND sg13cmos5l_dfrbpq_1
Xu_dll_u_control__2183_ u_dll_u_control__2183_/Q u_dll_u_control__2185_/CLK u_dll_u_control__2183_/D
+ u_dll_u_control__2040_/Y VPWR VGND sg13cmos5l_dfrbpq_1
Xu_dll_u_control_fanout9 u_dll_u_control__1653_/A u_dll_u_control__1665_/A VPWR VGND
+ sg13cmos5l_buf_1
Xu_dll_u_div0__050_ u_dll_u_div0__050_/Y u_dll_u_div0__109_/Q VPWR VGND sg13cmos5l_inv_1
Xu_dll_u_ring_dstage\[11\].id_const0_u_hi u_dll_u_ring_dstage\[11\].id_const0_u_hi/L_HI
+ VPWR VGND sg13cmos5l_tiehi
Xu_dll_u_control__1967_ u_dll_u_control__1967_/Y u_dll_u_control__2035_/A VPWR VGND
+ sg13cmos5l_inv_1
Xu_dll_u_control__1898_ u_dll_u_control__2289_/D u_dll_u_control__1898_/A u_dll_u_control__2304_/Q
+ VPWR VGND sg13cmos5l_and2_1
Xu_dll_u_ring_dstage\[5\].id_core_delaymux1_u_a1 u_dll_u_ring_dstage\[5\].id_core_delaymux1_u_a1/Y
+ u_dll_u_ring_dstage\[5\].id_core_delaymux1_u_a1/A u_dll_u_ring_dstage\[5\].id_core_delaymux1_u_a1/B
+ VPWR VGND sg13cmos5l_nand2_2
XFILLER_46_215 VPWR VGND sg13cmos5l_decap_4
Xu_dll_u_div0_u_clkbuf_config_u_buf u_dll_u_div0__110_/CLK u_dll_u_div0_buffer_u_buf/X
+ VPWR VGND sg13cmos5l_buf_4
XFILLER_6_377 VPWR VGND sg13cmos5l_decap_4
XFILLER_10_373 VPWR VGND sg13cmos5l_fill_2
Xu_dll_u_control__1752_ u_dll_u_control__1752_/Y u_dll_u_control__1752_/A u_dll_u_control__1752_/B
+ VPWR VGND sg13cmos5l_nor2_1
Xu_dll_u_control__1821_ u_dll_u_control__1823_/C u_dll_u_control__1816_/X u_dll_u_control__1818_/X
+ u_dll_u_control__1817_/Y VPWR VGND sg13cmos5l_o21ai_1
Xu_dll_u_control__2304_ u_dll_u_control__2304_/Q u_dll_u_control__2308_/CLK u_dll_u_control__2304_/D
+ u_dll_u_control__1964_/Y VPWR VGND sg13cmos5l_dfrbpq_1
Xu_dll_u_control__1683_ u_dll_u_control__2311_/D u_dll_u_control__1683_/A u_dll_u_control__1913_/A
+ VPWR VGND sg13cmos5l_nor2_1
Xu_dll_u_ring_dstage\[0\].id_core_fast_decode_u_nor u_dll_u_ring_dstage\[0\].id_core_reset_gate_u_aoi/A2
+ u_dll_u_ring_dstage\[0\].id_core_delaymux1_u_a1/B u_dll_u_ring_dstage\[0\].id_core_long_gate_u_nand/B
+ VPWR VGND sg13cmos5l_nor2_2
Xu_dll_u_control__1117_ u_dll_u_control__1117_/X u_dll_u_control__2134_/Q u_dll_u_control__2274_/Q
+ VPWR VGND sg13cmos5l_xor2_1
Xu_dll_u_control__2097_ u_dll_u_control__2097_/Y u_dll_u_control__2099_/A VPWR VGND
+ sg13cmos5l_inv_1
Xu_dll_u_control__2166_ u_dll_u_control__2166_/Q u_dll_u_control__2296_/CLK u_dll_u_control__2166_/D
+ u_dll_u_control__2023_/Y VPWR VGND sg13cmos5l_dfrbpq_1
Xu_dll_u_control__2235_ u_dll_u_control__2235_/Q u_dll_u_control__2235_/CLK u_dll_u_control__2235_/D
+ u_dll_u_control__2092_/Y VPWR VGND sg13cmos5l_dfrbpq_1
Xu_dll_u_div0__102_ u_dll_u_div0__102_/Q u_dll_u_div0__056_/A u_dll_u_div0__102_/D
+ u_dll_u_div0__105_/RESET_B VPWR VGND sg13cmos5l_dfrbpq_1
Xu_dll_u_ring_dstage\[3\].id_core_delayint0_u_inv u_dll_u_ring_dstage\[3\].id_core_delaymux1_u_a0/A
+ u_dll_u_ring_dstage\[3\].id_core_delayinv1_u_inv/Y VPWR VGND sg13cmos5l_inv_1
Xu_dll_u_ring_dstage\[4\].id_core_merge_gate_u_nand u_dll_u_ring_dstage\[4\].id_core_reset_gate_u_aoi/B1
+ u_dll_u_ring_dstage\[4\].id_core_short_gate_u_nand/Y u_dll_u_ring_dstage\[4\].id_core_long_gate_u_nand/Y
+ u_dll_u_ring_dstage\[4\].id_core_reset_inv_u_inv/Y VPWR VGND sg13cmos5l_nand3_1
XFILLER_19_237 VPWR VGND sg13cmos5l_fill_1
XFILLER_42_262 VPWR VGND sg13cmos5l_decap_8
XFILLER_33_251 VPWR VGND sg13cmos5l_decap_4
Xu_dll_u_control__2020_ u_dll_u_control__2020_/Y u_dll_u_control__2093_/A VPWR VGND
+ sg13cmos5l_inv_1
Xu_dll_u_control__1666_ u_dll_u_control__2136_/D u_dll_u_control__2136_/Q u_dll_u_control__1665_/A
+ u_dll_u_control__1665_/Y VPWR VGND sg13cmos5l_a21o_1
Xu_dll_u_control__1735_ u_dll_u_control__1735_/Y u_dll_u_control__1746_/A u_dll_u_control__1735_/B
+ u_dll_u_control__1735_/C VPWR VGND sg13cmos5l_nand3_1
Xu_dll_u_control__1804_ u_dll_u_control__2232_/D u_dll_u_control__1809_/A u_dll_u_control__1804_/B
+ u_dll_u_control__1804_/C VPWR VGND sg13cmos5l_nor3_1
Xu_dll_u_control__1597_ u_dll_u_control__1599_/B u_dll_u_control__2142_/Q u_dll_u_control__1619_/B
+ VPWR VGND sg13cmos5l_nand2_1
Xu_dll_u_div0_u_clkbuf_out_u_buf u_pad0_u_buf/A u_dll_u_div0_u_clkbuf_out_u_buf/A
+ VPWR VGND sg13cmos5l_buf_16
XFILLER_17_33 VPWR VGND sg13cmos5l_fill_1
Xu_dll_u_control__2218_ u_dll_u_control__2218_/Q clkload6/A u_dll_u_control__2218_/D
+ u_dll_u_control__2075_/Y VPWR VGND sg13cmos5l_dfrbpq_1
Xu_dll_u_control__2149_ u_dll_u_control__2149_/Q u_dll_u_control__2231_/CLK u_dll_u_control__2149_/D
+ u_dll_u_control__2006_/Y VPWR VGND sg13cmos5l_dfrbpq_1
XFILLER_24_284 VPWR VGND sg13cmos5l_fill_1
Xu_dll_u_control_fanout11 u_dll_u_control__1246_/B u_dll_u_control__1204_/X VPWR VGND
+ sg13cmos5l_buf_1
Xu_dll_u_control_fanout88 u_dll_u_control__2105_/A u_dll_u_control__2125_/A VPWR VGND
+ sg13cmos5l_buf_1
Xu_dll_u_control_fanout44 u_dll_u_control__1925_/A u_dll_u_control__2324_/Q VPWR VGND
+ sg13cmos5l_buf_1
Xu_dll_u_control_fanout55 u_dll_u_control__1526_/A u_dll_u_control__1099_/A VPWR VGND
+ sg13cmos5l_buf_1
Xu_dll_u_control_fanout66 u_dll_u_control__2034_/A u_dll_u_control_fanout69/X VPWR
+ VGND sg13cmos5l_buf_1
Xu_dll_u_control_fanout22 u_dll_u_control__1397_/A2 u_dll_u_control__1385_/X VPWR
+ VGND sg13cmos5l_buf_1
Xu_dll_u_control_fanout33 u_dll_u_control__1924_/A1 u_dll_u_control__1386_/A VPWR
+ VGND sg13cmos5l_buf_1
Xu_dll_u_control_fanout77 u_dll_u_control__2094_/A u_dll_u_control_fanout78/X VPWR
+ VGND sg13cmos5l_buf_1
XFILLER_47_398 VPWR VGND sg13cmos5l_decap_4
Xu_dll_u_control__1520_ u_dll_u_control__1520_/Y u_dll_u_control__1528_/B VPWR VGND
+ sg13cmos5l_inv_1
Xu_dll_u_control__1451_ u_dll_u_control__1462_/A u_dll_u_control__2167_/Q u_dll_u_control__1451_/B
+ VPWR VGND sg13cmos5l_and2_1
Xu_dll_u_control__1382_ u_dll_u_control__1384_/B u_dll_u_control__1382_/A u_dll_u_control__2194_/Q
+ VPWR VGND sg13cmos5l_nor2b_1
Xu_dll_u_control__2003_ u_dll_u_control__2003_/Y u_dll_u_control__2083_/A VPWR VGND
+ sg13cmos5l_inv_1
Xclkbuf_4_6__f_u_dll\_controller_ring_clk u_dll_u_control__2314_/CLK clkbuf_3_3_0_u_dll\_controller_ring_clk/X
+ VPWR VGND sg13cmos5l_buf_8
Xu_dll_u_control__1649_ u_dll_u_control__1649_/Y u_dll_u_control__1653_/A u_dll_u_control__1649_/B
+ u_dll_u_control__1673_/C VPWR VGND sg13cmos5l_nor3_1
Xheichips26_multimode_dll_small_108 uio_oe[7] VPWR VGND sg13cmos5l_tielo
Xu_dll_u_control__1718_ u_dll_u_control__1723_/A u_dll_u_control__1718_/A u_dll_u_control__1734_/A
+ VPWR VGND sg13cmos5l_or2_1
Xheichips26_multimode_dll_small_119 uo_out[5] VPWR VGND sg13cmos5l_tielo
XFILLER_44_357 VPWR VGND sg13cmos5l_decap_8
XFILLER_12_210 VPWR VGND sg13cmos5l_decap_4
Xclkbuf_4_15_0_u_dll\_controller_ref_clk clkbuf_4_15_0_u_dll\_controller_ref_clk/X
+ clkbuf_2_3_0_u_dll\_controller_ref_clk/X VPWR VGND sg13cmos5l_buf_8
XFILLER_8_225 VPWR VGND sg13cmos5l_decap_8
Xclkbuf_3_1_0_u_dll\_controller_ring_clk clkbuf_3_1_0_u_dll\_controller_ring_clk/X
+ clkbuf_3_3_0_u_dll\_controller_ring_clk/A VPWR VGND sg13cmos5l_buf_8
Xu_dll_u_ring_dstage\[2\].id_core_short_gate_u_nand u_dll_u_ring_dstage\[2\].id_core_short_gate_u_nand/Y
+ u_dll_u_ring_dstage\[1\].id_core_reset_gate_u_aoi/Y u_dll_u_ring_dstage\[2\].id_core_short_gate_u_nand/B
+ VPWR VGND sg13cmos5l_nand2_1
XFILLER_35_379 VPWR VGND sg13cmos5l_fill_1
XFILLER_35_357 VPWR VGND sg13cmos5l_fill_2
Xu_dll_u_control__1503_ u_dll_u_control__1505_/B u_dll_u_control__2182_/Q u_dll_u_control__1506_/B
+ VPWR VGND sg13cmos5l_nor2_1
Xu_dll_u_control__1434_ u_dll_u_control__1435_/B u_dll_u_control__2177_/Q u_dll_u_control__1438_/B
+ u_dll_u_control__1420_/B VPWR VGND sg13cmos5l_o21ai_1
Xu_dll_u_control__1365_ u_dll_u_control__2199_/D u_dll_u_control__1384_/A u_dll_u_control__1365_/B
+ u_dll_u_control__1365_/C VPWR VGND sg13cmos5l_nor3_1
Xu_dll_u_control__1296_ u_dll_u_control__1297_/B u_dll_u_control__2131_/Q u_dll_u_control__1296_/B
+ VPWR VGND sg13cmos5l_nand2_1
XFILLER_14_34 VPWR VGND sg13cmos5l_fill_1
Xu_dll_u_ring_dstage\[3\].id_core_trim_reset_inv_u_inv u_dll_u_ring_dstage\[3\].id_core_trim_reset_inv_u_inv/Y
+ u_dll_u_ring_trim_reset_buffers\[1\].u_buffer_u_buf/X VPWR VGND sg13cmos5l_inv_2
XFILLER_39_31 VPWR VGND sg13cmos5l_fill_2
XFILLER_39_53 VPWR VGND sg13cmos5l_fill_1
XFILLER_17_302 VPWR VGND sg13cmos5l_decap_8
XFILLER_17_313 VPWR VGND sg13cmos5l_fill_1
XFILLER_40_382 VPWR VGND sg13cmos5l_fill_2
Xu_dll_u_ring_dstage\[3\].id_core_trim_sync\[0\].applied_u_ff u_dll_u_ring_dstage\[3\].id_core_delaymux1_u_a1/B
+ u_dll_u_ring_dstage\[3\].id_core_delayinv1_u_inv/Y u_dll_u_ring_dstage\[3\].id_core_trim_sync\[0\].meta_u_ff/Q
+ u_dll_u_ring_dstage\[3\].id_core_trim_reset_inv_u_inv/Y VPWR VGND sg13cmos5l_dfrbpq_1
Xu_dll_u_control__1150_ u_dll_u_control__1150_/Y u_dll_u_control__2142_/Q u_dll_u_control__1151_/B
+ VPWR VGND sg13cmos5l_xnor2_1
XFILLER_35_198 VPWR VGND sg13cmos5l_fill_1
XFILLER_35_176 VPWR VGND sg13cmos5l_decap_4
XFILLER_23_316 VPWR VGND sg13cmos5l_fill_2
Xu_dll_u_control__1081_ u_dll_u_control__1322_/A u_dll_u_control__2195_/Q VPWR VGND
+ sg13cmos5l_inv_1
Xu_dll_u_control__1983_ u_dll_u_control__1983_/Y u_dll_u_control__2082_/A VPWR VGND
+ sg13cmos5l_inv_1
XFILLER_26_121 VPWR VGND sg13cmos5l_fill_1
Xu_dll_u_control__1279_ u_dll_u_control__1280_/A u_dll_u_control__1859_/A u_dll_u_control__1850_/B
+ u_dll_u_control__1860_/A VPWR VGND sg13cmos5l_a21o_1
Xu_dll_u_control__1348_ u_dll_u_control__1349_/C u_dll_u_control__2202_/Q u_dll_u_control_fanout32/X
+ VPWR VGND sg13cmos5l_nor2b_1
Xu_dll_u_control__1417_ u_dll_u_control__1418_/A u_dll_u_control__1417_/A u_dll_u_control__1417_/B
+ u_dll_u_control__1417_/C u_dll_u_control__1417_/D VPWR VGND sg13cmos5l_nor4_2
Xu_dll_u_ring_dstage\[2\].id_core_long_gate_u_nand u_dll_u_ring_dstage\[2\].id_core_long_gate_u_nand/Y
+ u_dll_u_ring_dstage\[2\].id_core_long_gate_u_nand/A u_dll_u_ring_dstage\[2\].id_core_long_gate_u_nand/B
+ VPWR VGND sg13cmos5l_nand2_2
Xu_dll_u_ring_dstage\[3\].id_core_fast_decode_u_nor u_dll_u_ring_dstage\[3\].id_core_reset_gate_u_aoi/A2
+ u_dll_u_ring_dstage\[3\].id_core_delaymux1_u_a1/B u_dll_u_ring_dstage\[3\].id_core_long_gate_u_nand/B
+ VPWR VGND sg13cmos5l_nor2_2
XFILLER_26_176 VPWR VGND sg13cmos5l_fill_1
Xu_dll_u_div1__100_ u_dll_u_div1__100_/Q u_dll_u_div1__056_/Y u_dll_u_div1__100_/D
+ u_dll_u_div1__105_/RESET_B VPWR VGND sg13cmos5l_dfrbpq_1
XFILLER_2_15 VPWR VGND sg13cmos5l_decap_8
XFILLER_49_268 VPWR VGND sg13cmos5l_decap_4
Xu_dll_u_ring_dstage\[7\].id_core_merge_gate_u_nand u_dll_u_ring_dstage\[7\].id_core_reset_gate_u_aoi/B1
+ u_dll_u_ring_dstage\[7\].id_core_short_gate_u_nand/Y u_dll_u_ring_dstage\[7\].id_core_long_gate_u_nand/Y
+ u_dll_u_ring_dstage\[7\].id_core_reset_inv_u_inv/Y VPWR VGND sg13cmos5l_nand3_1
XFILLER_13_371 VPWR VGND sg13cmos5l_decap_4
Xu_dll_u_control__2320_ u_dll_u_control__2320_/Q u_dll_u_control__2324_/CLK ui_in[0]
+ u_dll_u_control__1980_/Y VPWR VGND sg13cmos5l_dfrbpq_1
Xu_dll_u_control__1133_ u_dll_u_control__1133_/Y u_dll_u_control__1142_/B u_dll_u_control__1142_/C
+ u_dll_u_control__1130_/Y VPWR VGND sg13cmos5l_o21ai_1
Xu_dll_u_control__1202_ u_dll_u_control__1202_/Y u_dll_u_control__1202_/A u_dll_u_control__1202_/B
+ VPWR VGND sg13cmos5l_nor2_1
Xu_dll_u_control__2182_ u_dll_u_control__2182_/Q u_dll_u_control__2185_/CLK u_dll_u_control__2182_/D
+ u_dll_u_control__2039_/Y VPWR VGND sg13cmos5l_dfrbpq_1
Xu_dll_u_control__2251_ u_dll_u_control__2251_/Q clkload4/A u_dll_u_control__2251_/D
+ u_dll_u_control__2108_/Y VPWR VGND sg13cmos5l_dfrbpq_1
Xu_dll_u_control__1897_ u_dll_u_control__2288_/D u_dll_u_control__1898_/A u_dll_u_control__2303_/Q
+ VPWR VGND sg13cmos5l_and2_1
Xu_dll_u_control__1966_ u_dll_u_control__1966_/Y u_dll_u_control__2049_/A VPWR VGND
+ sg13cmos5l_inv_1
Xu_dll_u_ring_dstage\[8\].id_core_slow_isolation_u_buf u_dll_u_ring_dstage\[8\].id_core_delaymux1_u_a1/A
+ u_dll_u_ring_dstage\[7\].id_core_reset_gate_u_aoi/Y VPWR VGND sg13cmos5l_buf_2
XFILLER_46_227 VPWR VGND sg13cmos5l_decap_4
XFILLER_36_21 VPWR VGND sg13cmos5l_fill_2
Xclkbuf_5_4__f_u_dll\_controller_ref_clk u_dll_u_control__2312_/CLK clkbuf_4_2_0_u_dll\_controller_ref_clk/X
+ VPWR VGND sg13cmos5l_buf_8
XFILLER_10_396 VPWR VGND sg13cmos5l_decap_8
XFILLER_45_271 VPWR VGND sg13cmos5l_fill_2
Xu_dll_u_control__1751_ u_dll_u_control__1752_/B u_dll_u_control__2224_/Q u_dll_u_control__1537_/B
+ u_dll_u_control__1728_/A u_dll_u_control__1772_/B VPWR VGND sg13cmos5l_a22oi_1
Xu_dll_u_control__1682_ u_dll_u_control__2312_/D u_dll_u_control__1913_/A u_dll_u_control__1682_/B
+ VPWR VGND sg13cmos5l_nor2_1
Xu_dll_u_ring_dstage\[4\].id_core_delayinv1_u_inv u_dll_u_ring_dstage\[4\].id_core_delayinv1_u_inv/Y
+ u_dll_u_ring_dstage\[4\].id_core_delayinv1_u_inv/A VPWR VGND sg13cmos5l_inv_2
Xu_dll_u_control__1820_ u_dll_u_control__2235_/D u_dll_u_control__1816_/X u_dll_u_control__1818_/X
+ u_dll_u_control__1819_/Y VPWR VGND sg13cmos5l_a21oi_1
Xu_dll_u_control__2303_ u_dll_u_control__2303_/Q u_dll_u_control__2308_/CLK u_dll_u_control__2303_/D
+ u_dll_u_control__1963_/Y VPWR VGND sg13cmos5l_dfrbpq_1
XFILLER_3_80 VPWR VGND sg13cmos5l_fill_1
Xu_dll_u_control__2234_ u_dll_u_control__2234_/Q u_dll_u_control__2235_/CLK u_dll_u_control__2234_/D
+ u_dll_u_control__2091_/Y VPWR VGND sg13cmos5l_dfrbpq_1
Xu_dll_u_control__1116_ u_dll_u_control__1116_/Y u_dll_u_control__1114_/Y u_dll_u_control__1115_/Y
+ u_dll_u_control__1113_/Y VPWR VGND sg13cmos5l_o21ai_1
Xu_dll_u_control__2096_ u_dll_u_control__2096_/Y u_dll_u_control__2099_/A VPWR VGND
+ sg13cmos5l_inv_1
Xu_dll_u_div0__101_ u_dll_u_div0__101_/Q u_dll_u_div0__056_/A u_dll_u_div0__101_/D
+ u_dll_u_div0__105_/RESET_B VPWR VGND sg13cmos5l_dfrbpq_1
Xu_dll_u_control__2165_ u_dll_u_control__2165_/Q u_dll_u_control__2309_/CLK u_dll_u_control__2165_/D
+ u_dll_u_control__2022_/Y VPWR VGND sg13cmos5l_dfrbpq_1
Xu_dll_u_control__1949_ u_dll_u_control__1949_/Y u_dll_u_control__2060_/A VPWR VGND
+ sg13cmos5l_inv_1
Xu_dll_u_ring_dstage\[10\].id_core_delaymux1_u_a0 u_dll_u_ring_dstage\[10\].id_core_delaymux1_u_a0/Y
+ u_dll_u_ring_dstage\[10\].id_core_delaymux1_u_a0/A u_dll_u_ring_dstage\[10\].id_core_delaymux1_u_a0/B
+ VPWR VGND sg13cmos5l_nand2_2
Xu_dll_u_ring_dstage\[5\].id_core_short_gate_u_nand u_dll_u_ring_dstage\[5\].id_core_short_gate_u_nand/Y
+ u_dll_u_ring_dstage\[4\].id_core_reset_gate_u_aoi/Y u_dll_u_ring_dstage\[5\].id_core_short_gate_u_nand/B
+ VPWR VGND sg13cmos5l_nand2_1
XFILLER_26_4 VPWR VGND sg13cmos5l_fill_2
Xu_dll_u_control__1803_ u_dll_u_control__1804_/C u_dll_u_control__1803_/A u_dll_u_control__1803_/B
+ VPWR VGND sg13cmos5l_nor2_1
Xu_dll_u_control__1665_ u_dll_u_control__1665_/Y u_dll_u_control__1665_/A u_dll_u_control__1665_/B
+ u_dll_u_control__1673_/C VPWR VGND sg13cmos5l_nor3_1
Xu_dll_u_control__1734_ u_dll_u_control__1735_/C u_dll_u_control__1734_/A u_dll_u_control__1734_/B
+ u_dll_u_control__1734_/C VPWR VGND sg13cmos5l_nor3_1
Xu_dll_u_control__1596_ u_dll_u_control__1599_/A u_dll_u_control__1596_/A u_dll_u_control__1628_/B
+ u_dll_u_control__1627_/A VPWR VGND sg13cmos5l_nor3_1
Xu_dll_u_control__2217_ u_dll_u_control__2217_/Q u_dll_u_control__2271_/CLK u_dll_u_control__2217_/D
+ u_dll_u_control__2074_/Y VPWR VGND sg13cmos5l_dfrbpq_1
XFILLER_33_88 VPWR VGND sg13cmos5l_decap_8
Xu_dll_u_control__2148_ u_dll_u_control__2148_/Q u_dll_u_control__2322_/CLK u_dll_u_control__2148_/D
+ u_dll_u_control__2005_/Y VPWR VGND sg13cmos5l_dfrbpq_1
Xu_dll_u_control__2079_ u_dll_u_control__2079_/Y u_dll_u_control__2105_/A VPWR VGND
+ sg13cmos5l_inv_1
Xu_dll_u_control_fanout56 u_dll_u_control__1785_/A u_dll_u_control__1099_/A VPWR VGND
+ sg13cmos5l_buf_1
Xu_dll_u_control_fanout45 u_dll_u_control__1926_/A u_dll_u_control__1812_/B VPWR VGND
+ sg13cmos5l_buf_1
Xu_dll_u_control_fanout89 u_dll_u_control__2125_/A u_dll_u_control__2077_/A VPWR VGND
+ sg13cmos5l_buf_1
Xu_dll_u_control_fanout34 u_dll_u_control__1386_/A u_dll_u_control__2315_/Q VPWR VGND
+ sg13cmos5l_buf_1
Xu_dll_u_control_fanout23 u_dll_u_control__1384_/A u_dll_u_control__1345_/A VPWR VGND
+ sg13cmos5l_buf_1
Xu_dll_u_control_fanout67 u_dll_u_control__2049_/A u_dll_u_control_fanout69/X VPWR
+ VGND sg13cmos5l_buf_1
Xu_dll_u_control_fanout12 u_dll_u_control__1508_/A u_dll_u_control__1470_/X VPWR VGND
+ sg13cmos5l_buf_1
Xu_dll_u_control_fanout78 u_dll_u_control_fanout78/X u_dll__20_/Y VPWR VGND sg13cmos5l_buf_1
XFILLER_47_377 VPWR VGND sg13cmos5l_decap_8
XFILLER_47_322 VPWR VGND sg13cmos5l_decap_4
XFILLER_47_311 VPWR VGND sg13cmos5l_fill_2
Xu_dll_u_control__1450_ u_dll_u_control__2172_/D u_dll_u_control__2172_/Q u_dll_u_control__1454_/B
+ u_dll_u_control__1449_/Y VPWR VGND sg13cmos5l_a21oi_1
Xclkbuf_5_15__f_u_dll\_controller_ref_clk u_dll_u_control__2317_/CLK clkbuf_4_7_0_u_dll\_controller_ref_clk/X
+ VPWR VGND sg13cmos5l_buf_8
Xu_dll_u_control__1381_ u_dll_u_control__2195_/D u_dll_u_control__1384_/A u_dll_u_control__1381_/B
+ u_dll_u_control__1381_/C VPWR VGND sg13cmos5l_nor3_1
XFILLER_17_0 VPWR VGND sg13cmos5l_decap_4
Xu_dll_u_control__2002_ u_dll_u_control__2002_/Y u_dll_u_control__2002_/A VPWR VGND
+ sg13cmos5l_inv_1
XFILLER_21_211 VPWR VGND sg13cmos5l_fill_2
XFILLER_48_108 VPWR VGND sg13cmos5l_fill_2
Xu_dll_u_control__1579_ u_dll_u_control__1588_/B u_dll_u_control__2135_/Q u_dll_u_control__2241_/Q
+ VPWR VGND sg13cmos5l_nor2_1
Xu_dll_u_control__1648_ u_dll_u_control__2144_/D u_dll_u_control__2144_/Q u_dll_u_control__1661_/A
+ u_dll_u_control__1647_/Y VPWR VGND sg13cmos5l_a21o_1
Xu_dll_u_control__1717_ u_dll_u_control__2219_/D u_dll_u_control__1718_/A u_dll_u_control__1715_/Y
+ u_dll_u_control__1716_/Y VPWR VGND sg13cmos5l_o21ai_1
Xheichips26_multimode_dll_small_109 uio_out[0] VPWR VGND sg13cmos5l_tielo
XFILLER_29_399 VPWR VGND sg13cmos5l_decap_4
Xu_dll_u_ring_dstage\[6\].id_core_fast_decode_u_nor u_dll_u_ring_dstage\[6\].id_core_reset_gate_u_aoi/A2
+ u_dll_u_ring_dstage\[6\].id_core_delaymux1_u_a1/B u_dll_u_ring_dstage\[6\].id_core_long_gate_u_nand/B
+ VPWR VGND sg13cmos5l_nor2_2
Xu_dll_u_control__1226__124 u_dll_u_control__1226_/B VPWR VGND sg13cmos5l_tiehi
XFILLER_47_174 VPWR VGND sg13cmos5l_fill_1
XFILLER_35_336 VPWR VGND sg13cmos5l_fill_2
Xu_dll_u_ring_dstage\[7\].id_core_delaymux1_u_sel u_dll_u_ring_dstage\[7\].id_core_delaymux1_u_a0/B
+ u_dll_u_ring_dstage\[7\].id_core_delaymux1_u_a1/B VPWR VGND sg13cmos5l_inv_1
Xu_dll_u_control__1433_ u_dll_u_control__2178_/D u_dll_u_control__2178_/Q u_dll_u_control__1435_/A
+ u_dll_u_control__1432_/Y VPWR VGND sg13cmos5l_a21oi_1
Xu_dll_u_control__1502_ u_dll_u_control__2155_/D u_dll_u_control__1508_/A u_dll_u_control__1502_/B
+ u_dll_u_control__1502_/C VPWR VGND sg13cmos5l_nor3_1
XFILLER_38_196 VPWR VGND sg13cmos5l_fill_2
XFILLER_38_174 VPWR VGND sg13cmos5l_fill_1
Xu_dll_u_control__1364_ u_dll_u_control__1365_/C u_dll_u_control__2199_/Q u_dll_u_control_fanout32/X
+ VPWR VGND sg13cmos5l_nor2b_1
Xclkbuf_4_1_0_u_dll\_controller_ref_clk clkbuf_4_1_0_u_dll\_controller_ref_clk/X clkbuf_4_3_0_u_dll\_controller_ref_clk/A
+ VPWR VGND sg13cmos5l_buf_8
Xu_dll_u_control__1295_ u_dll_u_control__1296_/B u_dll_u_control__1465_/B VPWR VGND
+ sg13cmos5l_inv_1
XFILLER_30_34 VPWR VGND sg13cmos5l_fill_2
Xu_dll__39_ u_dll__40_/D u_dll__34_/Y u_dll__39_/D u_dll__23_/X VPWR VGND sg13cmos5l_dfrbpq_1
XFILLER_1_402 VPWR VGND sg13cmos5l_fill_2
XFILLER_29_130 VPWR VGND sg13cmos5l_fill_1
XFILLER_32_328 VPWR VGND sg13cmos5l_fill_2
XFILLER_4_295 VPWR VGND sg13cmos5l_decap_8
Xu_dll_u_control__1080_ u_dll_u_control__1351_/A u_dll_u_control__2197_/Q VPWR VGND
+ sg13cmos5l_inv_1
Xu_dll_u_div0_u_bypass_mux_u_merge u_dll_u_div0_u_run_gate_u_and/A u_dll_u_div0_u_bypass_mux_u_a0/Y
+ u_dll_u_div0_u_bypass_mux_u_a1/Y VPWR VGND sg13cmos5l_nand2_2
XFILLER_31_350 VPWR VGND sg13cmos5l_decap_4
Xu_dll_u_control__1982_ u_dll_u_control__1982_/Y u_dll_u_control__2082_/A VPWR VGND
+ sg13cmos5l_inv_1
Xu_dll_u_control__1416_ u_dll_u_control__1417_/D u_dll_u_control__2291_/Q u_dll_u_control__2297_/Q
+ VPWR VGND sg13cmos5l_xor2_1
Xu_dll_u_control__1347_ u_dll_u_control__1349_/B u_dll_u_control__1342_/B u_dll_u_control__1346_/X
+ u_dll_u_control__1924_/A1 VPWR VGND sg13cmos5l_a21oi_1
XFILLER_22_394 VPWR VGND sg13cmos5l_decap_8
XFILLER_25_89 VPWR VGND sg13cmos5l_fill_1
Xu_dll_u_control__1278_ u_dll_u_control__2267_/D u_dll_u_control__2283_/D u_dll_u_control__1277_/X
+ u_dll_u_control__2262_/D VPWR VGND sg13cmos5l_a21o_1
XFILLER_49_247 VPWR VGND sg13cmos5l_decap_8
XFILLER_9_398 VPWR VGND sg13cmos5l_decap_4
XFILLER_13_361 VPWR VGND sg13cmos5l_fill_1
Xu_dll_u_ring_dstage\[6\].id_core_reset_gate_u_aoi u_dll_u_ring_dstage\[6\].id_core_reset_gate_u_aoi/Y
+ u_dll_u_ring_dstage\[5\].id_core_reset_gate_u_aoi/Y u_dll_u_ring_dstage\[6\].id_core_reset_gate_u_aoi/A2
+ u_dll_u_ring_dstage\[6\].id_core_reset_gate_u_aoi/B1 VPWR VGND sg13cmos5l_a21oi_2
Xu_dll_u_control__2250_ u_dll_u_control__2250_/Q u_dll_u_control__2285_/CLK u_dll_u_control__2250_/D
+ u_dll_u_control__2107_/Y VPWR VGND sg13cmos5l_dfrbpq_1
Xu_dll_u_control__1132_ u_dll_u_control__1151_/B u_dll_u_control__1106_/Y u_dll_u_control__1885_/A
+ u_dll_u_control__1131_/Y VPWR VGND sg13cmos5l_a21oi_1
Xu_dll_u_control__1201_ u_dll_u_control__1202_/B u_dll_u_control__1201_/A u_dll_u_control__1230_/A
+ VPWR VGND sg13cmos5l_nor2_1
Xu_dll_u_ring_dstage\[8\].id_core_short_gate_u_nand u_dll_u_ring_dstage\[8\].id_core_short_gate_u_nand/Y
+ u_dll_u_ring_dstage\[7\].id_core_reset_gate_u_aoi/Y u_dll_u_ring_dstage\[8\].id_core_short_gate_u_nand/B
+ VPWR VGND sg13cmos5l_nand2_1
Xu_dll_u_control__2181_ u_dll_u_control__2181_/Q u_dll_u_control__2199_/CLK u_dll_u_control__2181_/D
+ u_dll_u_control__2038_/Y VPWR VGND sg13cmos5l_dfrbpq_1
XFILLER_31_180 VPWR VGND sg13cmos5l_decap_8
Xu_dll_u_control__1965_ u_dll_u_control__1965_/Y u_dll_u_control__2060_/A VPWR VGND
+ sg13cmos5l_inv_1
Xu_dll_u_ring_dstage\[7\].id_core_reset_inv_u_inv u_dll_u_ring_dstage\[7\].id_core_reset_inv_u_inv/Y
+ u_dll_u_ring_dstage\[7\].id_const0_u_lo/L_LO VPWR VGND sg13cmos5l_inv_1
Xu_dll_u_ring_dstage\[11\].id_const0_u_lo u_dll_u_ring_dstage\[11\].id_const0_u_lo/L_LO
+ VPWR VGND sg13cmos5l_tielo
Xu_dll_u_control__1896_ u_dll_u_control__2287_/D u_dll_u_control__1896_/A u_dll_u_control__2302_/Q
+ VPWR VGND sg13cmos5l_and2_1
XFILLER_36_66 VPWR VGND sg13cmos5l_fill_2
Xu_dll_u_ring_dstage\[11\].id_core_trim_sync\[0\].applied_u_ff u_dll_u_ring_dstage\[11\].id_core_delaymux1_u_a1/B
+ u_dll_u_ring_dstage\[11\].id_core_delayinv1_u_inv/Y u_dll_u_ring_dstage\[11\].id_core_trim_sync\[0\].meta_u_ff/Q
+ u_dll_u_ring_dstage\[11\].id_core_trim_reset_inv_u_inv/Y VPWR VGND sg13cmos5l_dfrbpq_1
XFILLER_9_173 VPWR VGND sg13cmos5l_fill_1
Xu_dll_u_control__1750_ u_dll_u_control__1750_/Y u_dll_u_control__1785_/A u_dll_u_control__1750_/B
+ VPWR VGND sg13cmos5l_nand2_1
Xu_dll_u_control__1681_ u_dll_u_control__2128_/D u_dll_u_control__1565_/A u_dll_u_control__1680_/Y
+ u_dll_u_control__1679_/Y VPWR VGND sg13cmos5l_o21ai_1
XFILLER_3_92 VPWR VGND sg13cmos5l_fill_1
Xu_dll_u_control__2302_ u_dll_u_control__2302_/Q clkload0/A u_dll_u_control__2302_/D
+ u_dll_u_control__1962_/Y VPWR VGND sg13cmos5l_dfrbpq_1
Xu_dll_u_control__2233_ u_dll_u_control__2233_/Q clkload3/A u_dll_u_control__2233_/D
+ u_dll_u_control__2090_/Y VPWR VGND sg13cmos5l_dfrbpq_1
Xu_dll_u_control__1115_ u_dll_u_control__1115_/Y u_dll_u_control__2133_/Q u_dll_u_control__2273_/Q
+ VPWR VGND sg13cmos5l_xnor2_1
Xu_dll_u_control__2095_ u_dll_u_control__2095_/Y u_dll_u_control__2095_/A VPWR VGND
+ sg13cmos5l_inv_1
Xu_dll_u_div0__100_ u_dll_u_div0__100_/Q u_dll_u_div0__056_/Y u_dll_u_div0__100_/D
+ u_dll_u_div0__105_/RESET_B VPWR VGND sg13cmos5l_dfrbpq_1
Xu_dll_u_control__2164_ u_dll_u_control__2164_/Q u_dll_u_control__2309_/CLK u_dll_u_control__2164_/D
+ u_dll_u_control__2021_/Y VPWR VGND sg13cmos5l_dfrbpq_1
Xu_dll_u_control__1948_ u_dll_u_control__1948_/Y u_dll_u_control__2035_/A VPWR VGND
+ sg13cmos5l_inv_1
Xu_dll_u_ring_dstage\[10\].id_core_delaymux1_u_a1 u_dll_u_ring_dstage\[10\].id_core_delaymux1_u_a1/Y
+ u_dll_u_ring_dstage\[10\].id_core_delaymux1_u_a1/A u_dll_u_ring_dstage\[10\].id_core_delaymux1_u_a1/B
+ VPWR VGND sg13cmos5l_nand2_2
Xu_dll_u_control__1879_ u_dll_u_control__1880_/C u_dll_u_control__1879_/A u_dll_u_control__1879_/B
+ u_dll_u_control__1879_/C VPWR VGND sg13cmos5l_and3_1
Xu_dll_u_ring_dstage\[9\].id_core_fast_decode_u_nor u_dll_u_ring_dstage\[9\].id_core_reset_gate_u_aoi/A2
+ u_dll_u_ring_dstage\[9\].id_core_delaymux1_u_a1/B u_dll_u_ring_dstage\[9\].id_core_long_gate_u_nand/B
+ VPWR VGND sg13cmos5l_nor2_2
Xu_dll_u_ring_dstage\[6\].id_core_delaybuf1_u_buf u_dll_u_ring_dstage\[6\].id_core_delayinv1_u_inv/A
+ u_dll_u_ring_dstage\[6\].id_core_delaymux1_u_a1/A VPWR VGND sg13cmos5l_buf_1
XFILLER_19_4 VPWR VGND sg13cmos5l_decap_8
XFILLER_18_250 VPWR VGND sg13cmos5l_fill_2
Xu_dll_u_control__1733_ u_dll_u_control__1734_/C u_dll_u_control__1299_/A u_dll_u_control__1550_/C
+ u_dll_u_control__1612_/B VPWR VGND sg13cmos5l_o21ai_1
Xu_dll_u_control__1802_ u_dll_u_control__1804_/B u_dll_u_control__1803_/A u_dll_u_control__1803_/B
+ VPWR VGND sg13cmos5l_and2_1
Xu_dll_u_control__1664_ u_dll_u_control__2137_/D u_dll_u_control__2137_/Q u_dll_u_control__1661_/A
+ u_dll_u_control__1663_/Y VPWR VGND sg13cmos5l_a21o_1
Xu_dll_u_control__1595_ u_dll_u_control__1627_/A u_dll_u_control__2141_/Q u_dll_u_control__1629_/B
+ VPWR VGND sg13cmos5l_xor2_1
Xu_dll_u_control__2216_ u_dll_u_control__2216_/Q u_dll_u_control__2223_/CLK u_dll_u_control__2216_/D
+ u_dll_u_control__2073_/Y VPWR VGND sg13cmos5l_dfrbpq_1
Xu_dll_u_control__2147_ u_dll_u_control__2147_/Q u_dll_u_control__2322_/CLK u_dll_u_control__2147_/D
+ u_dll_u_control__2004_/Y VPWR VGND sg13cmos5l_dfrbpq_1
XFILLER_33_78 VPWR VGND sg13cmos5l_fill_1
Xu_dll_u_control__2078_ u_dll_u_control__2078_/Y u_dll_u_control__2105_/A VPWR VGND
+ sg13cmos5l_inv_1
Xu_dll_u_control_fanout24 u_dll_u_control__1392_/B u_dll_u_control__1398_/B VPWR VGND
+ sg13cmos5l_buf_4
Xu_dll_u_control_fanout13 u_dll_u_control__1487_/A u_dll_u_control__1470_/X VPWR VGND
+ sg13cmos5l_buf_1
Xclkbuf_4_4_0_u_dll\_controller_ref_clk clkbuf_4_4_0_u_dll\_controller_ref_clk/X clkbuf_4_7_0_u_dll\_controller_ref_clk/A
+ VPWR VGND sg13cmos5l_buf_8
Xu_dll_u_control_fanout46 u_dll_u_control__1812_/B u_dll_u_control__2323_/Q VPWR VGND
+ sg13cmos5l_buf_1
Xu_dll_u_control_fanout35 u_dll_u_control__1752_/A u_dll_u_control__1299_/Y VPWR VGND
+ sg13cmos5l_buf_1
Xu_dll_u_control_fanout57 u_dll_u_control__1099_/A u_dll_u_control__2237_/Q VPWR VGND
+ sg13cmos5l_buf_1
Xu_dll_u_control_fanout79 u_dll_u_control__2124_/A u_dll_fanout80/X VPWR VGND sg13cmos5l_buf_1
Xu_dll_u_control_fanout68 u_dll_u_control__2023_/A u_dll_u_control_fanout69/X VPWR
+ VGND sg13cmos5l_buf_1
XFILLER_30_289 VPWR VGND sg13cmos5l_decap_4
Xu_dll_u_ring_dstage\[4\].id_core_trim_reset_inv_u_inv u_dll_u_ring_dstage\[4\].id_core_trim_reset_inv_u_inv/Y
+ u_dll_u_ring_trim_reset_buffers\[1\].u_buffer_u_buf/X VPWR VGND sg13cmos5l_inv_2
Xclkbuf_3_6_0_u_dll\_controller_ring_clk clkbuf_3_6_0_u_dll\_controller_ring_clk/X
+ clkbuf_3_7_0_u_dll\_controller_ring_clk/A VPWR VGND sg13cmos5l_buf_8
Xu_dll_u_control__2001_ u_dll_u_control__2001_/Y u_dll_u_control__2102_/A VPWR VGND
+ sg13cmos5l_inv_1
XFILLER_38_356 VPWR VGND sg13cmos5l_fill_2
Xu_dll_u_control__1380_ u_dll_u_control__1381_/C u_dll_u_control__2195_/Q u_dll_u_control__1382_/A
+ VPWR VGND sg13cmos5l_nor2b_1
Xu_dll_u_ring_dstage\[3\].id_core_secondary_inv_u_inv u_dll_u_ring_dstage\[3\].id_core_short_decode_u_and/B
+ u_dll_u_ring_dstage\[3\].id_core_long_gate_u_nand/B VPWR VGND sg13cmos5l_inv_1
Xu_dll_u_control__1716_ u_dll_u_control__1716_/Y u_dll_u_control__2223_/Q u_dll_u_control__2219_/Q
+ u_dll_u_control__1716_/C VPWR VGND sg13cmos5l_nand3b_1
Xu_dll_u_control__1578_ u_dll_u_control__1588_/A u_dll_u_control__2136_/Q u_dll_u_control__2242_/Q
+ VPWR VGND sg13cmos5l_xnor2_1
Xu_dll_u_control__1647_ u_dll_u_control__1647_/Y u_dll_u_control__1661_/A u_dll_u_control__1647_/B
+ u_dll_u_control__1673_/C VPWR VGND sg13cmos5l_nor3_1
Xclkbuf_5_21__f_u_dll\_controller_ref_clk clkload5/A clkbuf_4_10_0_u_dll\_controller_ref_clk/X
+ VPWR VGND sg13cmos5l_buf_8
XFILLER_5_27 VPWR VGND sg13cmos5l_fill_2
XFILLER_4_400 VPWR VGND sg13cmos5l_decap_4
XFILLER_10_8 VPWR VGND sg13cmos5l_fill_2
XFILLER_38_131 VPWR VGND sg13cmos5l_fill_2
Xu_dll_u_control__1432_ u_dll_u_control__1432_/Y u_dll_u_control__2178_/Q u_dll_u_control__1435_/A
+ u_dll_u_control__1420_/B VPWR VGND sg13cmos5l_o21ai_1
Xu_dll_u_control__1363_ u_dll_u_control__1365_/B u_dll_u_control__1358_/B u_dll_u_control__1362_/Y
+ u_dll_u_control__1371_/A VPWR VGND sg13cmos5l_a21oi_1
Xu_dll_u_control__1501_ u_dll_u_control__1502_/C u_dll_u_control__2155_/Q u_dll_u_control__1501_/B
+ VPWR VGND sg13cmos5l_nor2_1
Xu_dll_u_control__1294_ u_dll_u_control__1465_/B u_dll_u_control__2130_/Q u_dll_u_control__2310_/Q
+ VPWR VGND sg13cmos5l_xor2_1
Xu_dll__38_ u_dll__39_/D u_dll__33_/Y u_dll__38_/D u_dll__24_/X VPWR VGND sg13cmos5l_dfrbpq_1
XFILLER_29_142 VPWR VGND sg13cmos5l_fill_2
XFILLER_40_384 VPWR VGND sg13cmos5l_fill_1
XFILLER_4_274 VPWR VGND sg13cmos5l_decap_8
Xu_dll_u_ring_dstage\[9\].id_core_slow_isolation_u_buf u_dll_u_ring_dstage\[9\].id_core_delaymux1_u_a1/A
+ u_dll_u_ring_dstage\[8\].id_core_reset_gate_u_aoi/Y VPWR VGND sg13cmos5l_buf_2
XFILLER_35_112 VPWR VGND sg13cmos5l_fill_1
XFILLER_35_101 VPWR VGND sg13cmos5l_decap_8
XFILLER_35_156 VPWR VGND sg13cmos5l_fill_1
XFILLER_16_370 VPWR VGND sg13cmos5l_fill_2
Xu_dll_u_control__1981_ u_dll_u_control__1981_/Y u_dll_u_control__2083_/A VPWR VGND
+ sg13cmos5l_inv_1
Xu_dll_u_control__1346_ u_dll_u_control__1346_/X u_dll_u_control__2207_/Q u_dll_u_control__2202_/Q
+ VPWR VGND sg13cmos5l_or2_1
Xu_dll_u_control__1415_ u_dll_u_control__1417_/C u_dll_u_control__2293_/Q u_dll_u_control__2299_/Q
+ VPWR VGND sg13cmos5l_xor2_1
XFILLER_22_373 VPWR VGND sg13cmos5l_decap_8
Xu_dll_u_control__1277_ u_dll_u_control__1277_/X u_dll_u_control__1857_/A u_dll_u_control__1687_/B
+ u_dll_u_control__1844_/B u_dll_u_control__1863_/A VPWR VGND sg13cmos5l_and4_1
Xu_dll_u_ring_dstage\[7\].id_core_trim_sync\[1\].meta_u_ff u_dll_u_ring_dstage\[7\].id_core_trim_sync\[1\].meta_u_ff/Q
+ u_dll_u_ring_dstage\[7\].id_core_delayinv1_u_inv/Y u_dll_u_control__1071_/Y u_dll_u_ring_dstage\[7\].id_core_trim_reset_inv_u_inv/Y
+ VPWR VGND sg13cmos5l_dfrbpq_1
XFILLER_49_204 VPWR VGND sg13cmos5l_fill_1
Xclkbuf_5_9__f_u_dll\_controller_ref_clk clkload2/A clkbuf_4_4_0_u_dll\_controller_ref_clk/X
+ VPWR VGND sg13cmos5l_buf_8
XFILLER_32_159 VPWR VGND sg13cmos5l_decap_4
XFILLER_40_181 VPWR VGND sg13cmos5l_fill_2
XFILLER_40_170 VPWR VGND sg13cmos5l_decap_8
Xu_dll_u_ring_dstage\[8\].id_core_delaymux1_u_a0 u_dll_u_ring_dstage\[8\].id_core_delaymux1_u_a0/Y
+ u_dll_u_ring_dstage\[8\].id_core_delaymux1_u_a0/A u_dll_u_ring_dstage\[8\].id_core_delaymux1_u_a0/B
+ VPWR VGND sg13cmos5l_nand2_2
XFILLER_9_333 VPWR VGND sg13cmos5l_fill_2
XFILLER_13_395 VPWR VGND sg13cmos5l_decap_8
XFILLER_49_4 VPWR VGND sg13cmos5l_fill_1
Xu_dll_u_div1__089_ u_dll_u_div1__094_/B u_dll_u_div1__108_/Q u_dll_u_div1__102_/Q
+ VPWR VGND sg13cmos5l_xor2_1
Xu_dll_u_control__1200_ u_dll_u_control__1202_/A u_dll_u_control__1200_/A u_dll_u_control__1200_/B
+ VPWR VGND sg13cmos5l_nor2_1
Xu_dll_u_control__2180_ u_dll_u_control__2180_/Q u_dll_u_control__2298_/CLK u_dll_u_control__2180_/D
+ u_dll_u_control__2037_/Y VPWR VGND sg13cmos5l_dfrbpq_1
Xu_dll_u_control__1131_ u_dll_u_control__1131_/Y u_dll_u_control__1131_/A u_dll_u_control__1571_/A
+ VPWR VGND sg13cmos5l_nand2_1
Xu_dll_u_div0_buffer_u_buf u_dll_u_div0_buffer_u_buf/X u_dll_u_div1_buffer_u_buf/A
+ VPWR VGND sg13cmos5l_buf_4
Xu_dll_u_control__1895_ u_dll_u_control__2294_/D u_dll_u_control__1898_/A u_dll_u_control__2290_/Q
+ VPWR VGND sg13cmos5l_and2_1
Xu_dll_u_control__1964_ u_dll_u_control__1964_/Y u_dll_u_control__2060_/A VPWR VGND
+ sg13cmos5l_inv_1
Xu_dll_u_ring_dstage\[7\].id_core_long_gate_u_nand u_dll_u_ring_dstage\[7\].id_core_long_gate_u_nand/Y
+ u_dll_u_ring_dstage\[7\].id_core_long_gate_u_nand/A u_dll_u_ring_dstage\[7\].id_core_long_gate_u_nand/B
+ VPWR VGND sg13cmos5l_nand2_2
XFILLER_11_26 VPWR VGND sg13cmos5l_fill_1
Xu_dll_u_control__1329_ u_dll_u_control__1338_/B u_dll_u_control__2207_/Q u_dll_u_control__2203_/Q
+ u_dll_u_control__2202_/Q VPWR VGND sg13cmos5l_nand3_1
XFILLER_14_104 VPWR VGND sg13cmos5l_fill_1
Xu_dll_u_control__2316__127 u_dll_u_control__2316_/D VPWR VGND sg13cmos5l_tiehi
Xclkbuf_4_7_0_u_dll\_controller_ref_clk clkbuf_4_7_0_u_dll\_controller_ref_clk/X clkbuf_4_7_0_u_dll\_controller_ref_clk/A
+ VPWR VGND sg13cmos5l_buf_8
XFILLER_10_332 VPWR VGND sg13cmos5l_fill_1
XFILLER_7_0 VPWR VGND sg13cmos5l_decap_4
XFILLER_45_251 VPWR VGND sg13cmos5l_fill_2
XFILLER_33_402 VPWR VGND sg13cmos5l_fill_2
Xu_dll_u_control__1680_ u_dll_u_control__1680_/Y u_dll_u_control__2152_/Q u_dll_u_control__1567_/B
+ u_dll_u_control__2128_/Q VPWR VGND sg13cmos5l_a21oi_1
Xu_dll_u_control__2301_ u_dll_u_control__2301_/Q u_dll_u_control__2301_/CLK u_dll_u_control__2301_/D
+ u_dll_u_control__1961_/Y VPWR VGND sg13cmos5l_dfrbpq_1
Xu_dll_u_control__1114_ u_dll_u_control__1114_/Y u_dll_u_control__2132_/Q u_dll_u_control__2272_/Q
+ VPWR VGND sg13cmos5l_nand2_1
Xu_dll_u_control__2163_ u_dll_u_control__2163_/Q u_dll_u_control__2309_/CLK u_dll_u_control__2163_/D
+ u_dll_u_control__2020_/Y VPWR VGND sg13cmos5l_dfrbpq_1
Xu_dll_u_control__2232_ u_dll_u_control__2232_/Q clkload3/A u_dll_u_control__2232_/D
+ u_dll_u_control__2089_/Y VPWR VGND sg13cmos5l_dfrbpq_1
Xu_dll_u_control__2094_ u_dll_u_control__2094_/Y u_dll_u_control__2094_/A VPWR VGND
+ sg13cmos5l_inv_1
XFILLER_22_47 VPWR VGND sg13cmos5l_fill_2
Xu_dll_u_control__1878_ u_dll_u_control__2276_/D u_dll_u_control__1879_/B u_dll_u_control__1878_/B
+ u_dll_u_control__1878_/C VPWR VGND sg13cmos5l_and3_1
XFILLER_0_7 VPWR VGND sg13cmos5l_decap_8
Xu_dll_u_control__1947_ u_dll_u_control__1947_/Y u_dll_u_control__2049_/A VPWR VGND
+ sg13cmos5l_inv_1
Xu_dll_u_ring_dstage\[0\].id_core_short_decode_u_and u_dll_u_ring_dstage\[0\].id_core_short_gate_u_nand/B
+ u_dll_u_ring_dstage\[0\].id_core_delaymux1_u_a1/B u_dll_u_ring_dstage\[0\].id_core_short_decode_u_and/B
+ VPWR VGND sg13cmos5l_and2_2
Xu_dll_u_control__1732_ u_dll_u_control__1734_/B u_dll_u_control__1812_/B u_dll_u_control__1730_/B
+ u_dll_u_control__1550_/C u_dll_u_control__1299_/A u_dll_u_control__1731_/Y VPWR
+ VGND sg13cmos5l_a221oi_1
Xu_dll_u_control__1801_ u_dll_u_control__1803_/B u_dll_u_control__2161_/Q u_dll_u_control__2321_/Q
+ VPWR VGND sg13cmos5l_xor2_1
Xu_dll_u_control__1594_ u_dll_u_control__1628_/B u_dll_u_control__1574_/X u_dll_u_control__1630_/A
+ u_dll_u_control__1575_/X VPWR VGND sg13cmos5l_a21oi_1
Xu_dll_u_control__1663_ u_dll_u_control__1663_/Y u_dll_u_control__1665_/A u_dll_u_control__1663_/B
+ u_dll_u_control__1663_/C VPWR VGND sg13cmos5l_nor3_1
Xu_dll_u_div0_u_parity_mux_u_sel u_dll_u_div0_u_parity_mux_u_a0/B u_dll_u_div0__106_/Q
+ VPWR VGND sg13cmos5l_inv_1
Xu_dll_u_control__2215_ u_dll_u_control__2215_/Q u_dll_u_control__2280_/CLK u_dll_u_control__2215_/D
+ u_dll_u_control__2072_/Y VPWR VGND sg13cmos5l_dfrbpq_1
Xu_dll_u_control__2077_ u_dll_u_control__2077_/Y u_dll_u_control__2077_/A VPWR VGND
+ sg13cmos5l_inv_1
Xu_dll_u_control__2146_ u_dll_u_control__2146_/Q u_dll_u_control__2227_/CLK u_dll_u_control__2146_/D
+ u_dll_u_control__2003_/Y VPWR VGND sg13cmos5l_dfrbpq_1
Xu_dll_u_control_fanout58 u_dll_u_control__1618_/A u_dll_u_control__2145_/Q VPWR VGND
+ sg13cmos5l_buf_1
Xu_dll_u_control_fanout36 u_dll_u_control__1876_/A u_dll_u_control__1880_/B VPWR VGND
+ sg13cmos5l_buf_1
Xu_dll_u_control_fanout14 u_dll_u_control__1741_/B u_dll_u_control__1702_/A VPWR VGND
+ sg13cmos5l_buf_1
Xu_dll_u_control_fanout25 u_dll_u_control__1410_/B u_dll_u_control__1398_/B VPWR VGND
+ sg13cmos5l_buf_1
Xu_dll_u_control_fanout47 u_dll_u_control__1909_/A u_dll_u_control__2317_/Q VPWR VGND
+ sg13cmos5l_buf_1
Xu_dll_u_control_fanout69 u_dll_u_control_fanout69/X u_dll_u_control_fanout78/X VPWR
+ VGND sg13cmos5l_buf_1
Xu_dll_u_div0_u_odd_extend_u_or u_dll_u_div0_u_parity_mux_u_a1/A u_dll_u_div0__100_/D
+ u_dll_u_div0__100_/Q VPWR VGND sg13cmos5l_or2_1
XFILLER_38_368 VPWR VGND sg13cmos5l_fill_2
Xu_dll_u_control__2000_ u_dll_u_control__2000_/Y u_dll_u_control__2002_/A VPWR VGND
+ sg13cmos5l_inv_1
XFILLER_21_213 VPWR VGND sg13cmos5l_fill_1
Xu_dll_u_control__1646_ u_dll_u_control__1663_/C u_dll_u_control__1652_/B u_dll_u_control__1657_/B
+ VPWR VGND sg13cmos5l_nand2_1
Xu_dll_u_control__1715_ u_dll_u_control__1715_/Y u_dll_u_control__1715_/A u_dll_u_control__1715_/B
+ VPWR VGND sg13cmos5l_nand2_1
XFILLER_29_302 VPWR VGND sg13cmos5l_fill_2
Xu_dll_u_ring_dstage\[2\].id_const0_u_hi u_dll_u_ring_dstage\[2\].id_const0_u_hi/L_HI
+ VPWR VGND sg13cmos5l_tiehi
Xu_dll_u_control__1577_ u_dll_u_control__1577_/Y u_dll_u_control__2137_/Q u_dll_u_control__2243_/Q
+ VPWR VGND sg13cmos5l_nand2_1
XFILLER_29_324 VPWR VGND sg13cmos5l_fill_2
XFILLER_8_217 VPWR VGND sg13cmos5l_decap_4
XFILLER_12_268 VPWR VGND sg13cmos5l_fill_1
Xu_dll_u_control__2129_ u_dll_u_control__2129_/Q clkload1/A u_dll_u_control__2129_/D
+ u_dll_u_control__1986_/Y VPWR VGND sg13cmos5l_dfrbpq_1
XFILLER_43_393 VPWR VGND sg13cmos5l_decap_8
XFILLER_35_338 VPWR VGND sg13cmos5l_fill_1
Xu_dll_u_control__1500_ u_dll_u_control__1502_/B u_dll_u_control__2183_/Q u_dll_u_control__1506_/B
+ VPWR VGND sg13cmos5l_nor2_1
Xu_dll_u_control__1293_ u_dll_u_control__1469_/A u_dll_u_control__2214_/Q u_dll_u_control__2215_/Q
+ u_dll_u_control__2216_/Q u_dll_u_control__1701_/B VPWR VGND sg13cmos5l_nand4_1
Xu_dll_u_control__1431_ u_dll_u_control__1435_/A u_dll_u_control__2177_/Q u_dll_u_control__1438_/B
+ VPWR VGND sg13cmos5l_and2_1
Xu_dll_u_control__1362_ u_dll_u_control__1362_/Y u_dll_u_control__2199_/Q u_dll_u_control__1362_/B
+ VPWR VGND sg13cmos5l_nand2b_1
Xu_dll__37_ u_dll__38_/D u_dll__32_/Y u_dll__37_/D u_dll__25_/X VPWR VGND sg13cmos5l_dfrbpq_1
Xu_dll_u_div1_u_clkbuf_sample_u_buf u_dll_u_div1__115_/CLK u_dll_u_div1_buffer_u_buf/X
+ VPWR VGND sg13cmos5l_buf_4
Xu_dll_u_ring_dstage\[7\].id_core_trim_sync\[0\].meta_u_ff u_dll_u_ring_dstage\[7\].id_core_trim_sync\[0\].meta_u_ff/Q
+ u_dll_u_ring_dstage\[7\].id_core_delayinv1_u_inv/Y u_dll_u_control__2253_/Q u_dll_u_ring_dstage\[7\].id_core_trim_reset_inv_u_inv/Y
+ VPWR VGND sg13cmos5l_dfrbpq_1
Xu_dll_u_control__1629_ u_dll_u_control__1630_/B u_dll_u_control__2139_/Q u_dll_u_control__1629_/B
+ VPWR VGND sg13cmos5l_xor2_1
XFILLER_39_89 VPWR VGND sg13cmos5l_fill_1
XFILLER_39_78 VPWR VGND sg13cmos5l_fill_1
Xu_dll_u_ring_dstage\[2\].id_core_trim_sync\[1\].meta_u_ff u_dll_u_ring_dstage\[2\].id_core_trim_sync\[1\].meta_u_ff/Q
+ u_dll_u_ring_dstage\[2\].id_core_delayinv1_u_inv/Y u_dll_u_control__1076_/Y u_dll_u_ring_dstage\[2\].id_core_trim_reset_inv_u_inv/Y
+ VPWR VGND sg13cmos5l_dfrbpq_1
XFILLER_40_363 VPWR VGND sg13cmos5l_fill_2
XFILLER_4_253 VPWR VGND sg13cmos5l_decap_8
Xu_dll_u_control__1980_ u_dll_u_control__1980_/Y u_dll_u_control__2083_/A VPWR VGND
+ sg13cmos5l_inv_1
XFILLER_41_105 VPWR VGND sg13cmos5l_fill_1
Xu_dll_u_control__1276_ u_dll_u_control__2283_/D u_dll_u_control__1863_/B VPWR VGND
+ sg13cmos5l_inv_1
Xu_dll_u_control__1414_ u_dll_u_control__1417_/B u_dll_u_control__2292_/Q u_dll_u_control__2298_/Q
+ VPWR VGND sg13cmos5l_xor2_1
Xu_dll_u_control__1345_ u_dll_u_control__2203_/D u_dll_u_control__1345_/A u_dll_u_control__1345_/B
+ u_dll_u_control__1345_/C VPWR VGND sg13cmos5l_nor3_1
XFILLER_14_319 VPWR VGND sg13cmos5l_fill_1
XFILLER_22_352 VPWR VGND sg13cmos5l_decap_8
XFILLER_9_4 VPWR VGND sg13cmos5l_fill_1
XFILLER_49_227 VPWR VGND sg13cmos5l_decap_8
XFILLER_2_29 VPWR VGND sg13cmos5l_decap_8
XFILLER_13_385 VPWR VGND sg13cmos5l_fill_2
Xu_dll_u_ring_dstage\[8\].id_core_delaymux1_u_a1 u_dll_u_ring_dstage\[8\].id_core_delaymux1_u_a1/Y
+ u_dll_u_ring_dstage\[8\].id_core_delaymux1_u_a1/A u_dll_u_ring_dstage\[8\].id_core_delaymux1_u_a1/B
+ VPWR VGND sg13cmos5l_nand2_2
Xu_dll_u_ring_dstage\[11\].id_core_trim_sync\[1\].meta_u_ff u_dll_u_ring_dstage\[11\].id_core_trim_sync\[1\].meta_u_ff/Q
+ u_dll_u_ring_dstage\[11\].id_core_delayinv1_u_inv/Y u_dll_u_control__1067_/Y u_dll_u_ring_dstage\[11\].id_core_trim_reset_inv_u_inv/Y
+ VPWR VGND sg13cmos5l_dfrbpq_1
XFILLER_48_271 VPWR VGND sg13cmos5l_fill_2
Xu_dll_u_div1__088_ u_dll_u_div1__105_/D u_dll_u_div1__088_/A u_dll_u_div1__088_/B
+ VPWR VGND sg13cmos5l_nor2_1
Xu_dll_u_control__1130_ u_dll_u_control__1130_/Y u_dll_u_control__2141_/Q u_dll_u_control__2140_/Q
+ VPWR VGND sg13cmos5l_nor2_1
Xu_dll_u_control__1963_ u_dll_u_control__1963_/Y u_dll_u_control__2035_/A VPWR VGND
+ sg13cmos5l_inv_1
Xu_dll_u_control__1894_ u_dll_u_control__2293_/D u_dll_u_control__1898_/A u_dll_u_control__2289_/Q
+ VPWR VGND sg13cmos5l_and2_1
Xu_dll_u_ring_dstage\[7\].id_const0_u_hi u_dll_u_ring_dstage\[7\].id_const0_u_hi/L_HI
+ VPWR VGND sg13cmos5l_tiehi
Xu_dll_u_ring_dstage\[0\].id_core_delaymux1_u_sel u_dll_u_ring_dstage\[0\].id_core_delaymux1_u_a0/B
+ u_dll_u_ring_dstage\[0\].id_core_delaymux1_u_a1/B VPWR VGND sg13cmos5l_inv_1
XFILLER_46_219 VPWR VGND sg13cmos5l_fill_1
XFILLER_39_293 VPWR VGND sg13cmos5l_decap_4
XFILLER_42_403 VPWR VGND sg13cmos5l_fill_1
Xu_dll_u_control__1259_ u_dll_u_control__1849_/B u_dll_u_control__1183_/A u_dll_u_control__1260_/S
+ u_dll_u_control__1258_/Y VPWR VGND sg13cmos5l_o21ai_1
Xu_dll_u_control__1328_ u_dll_u_control__1342_/B u_dll_u_control__2207_/Q u_dll_u_control__2202_/Q
+ VPWR VGND sg13cmos5l_nand2_1
Xu_dll_u_ring_iss_core_long_gate_u_nand u_dll_u_ring_iss_core_long_gate_u_nand/Y u_dll_u_ring_iss_core_long_gate_u_nand/A
+ u_dll_u_ring_iss_core_long_gate_u_nand/B VPWR VGND sg13cmos5l_nand2_2
XFILLER_22_193 VPWR VGND sg13cmos5l_fill_2
Xu_dll_u_control__2300_ u_dll_u_control__2300_/Q u_dll_u_control__2300_/CLK u_dll_u_control__2300_/D
+ u_dll_u_control__1960_/Y VPWR VGND sg13cmos5l_dfrbpq_1
Xu_dll_u_control__1113_ u_dll_u_control__1113_/Y u_dll_u_control__2133_/Q u_dll_u_control__2273_/Q
+ VPWR VGND sg13cmos5l_nand2_1
Xu_dll_u_control__2231_ u_dll_u_control__2231_/Q u_dll_u_control__2231_/CLK u_dll_u_control__2231_/D
+ u_dll_u_control__2088_/Y VPWR VGND sg13cmos5l_dfrbpq_1
Xheichips26_multimode_dll_small analog_2 VPWR VGND sg13cmos5l_tielo
Xu_dll_u_control__2162_ u_dll_u_control__2162_/Q clkload0/A u_dll_u_control__2162_/D
+ u_dll_u_control__2019_/Y VPWR VGND sg13cmos5l_dfrbpq_1
Xu_dll_u_control__2093_ u_dll_u_control__2093_/Y u_dll_u_control__2093_/A VPWR VGND
+ sg13cmos5l_inv_1
Xu_dll_u_ring_dstage\[5\].id_core_trim_reset_inv_u_inv u_dll_u_ring_dstage\[5\].id_core_trim_reset_inv_u_inv/Y
+ u_dll_u_ring_trim_reset_buffers\[1\].u_buffer_u_buf/X VPWR VGND sg13cmos5l_inv_2
XFILLER_22_37 VPWR VGND sg13cmos5l_fill_2
Xu_dll_u_control__1877_ u_dll_u_control__1878_/C u_dll_u_control__1120_/B u_dll_u_control__1120_/C
+ u_dll_u_control__1120_/A VPWR VGND sg13cmos5l_o21ai_1
Xu_dll_u_control__1946_ u_dll_u_control__1946_/Y u_dll_u_control__2119_/A VPWR VGND
+ sg13cmos5l_inv_1
Xu_dll_u_div0__089_ u_dll_u_div0__094_/B u_dll_u_div0__108_/Q u_dll_u_div0__102_/Q
+ VPWR VGND sg13cmos5l_xor2_1
XFILLER_2_373 VPWR VGND sg13cmos5l_fill_2
XFILLER_18_252 VPWR VGND sg13cmos5l_fill_1
Xu_dll_u_control__1662_ u_dll_u_control__2138_/D u_dll_u_control__2138_/Q u_dll_u_control__1661_/A
+ u_dll_u_control__1661_/Y VPWR VGND sg13cmos5l_a21o_1
Xu_dll_u_div1_u_bypass_mux_u_sel u_dll_u_div1_u_bypass_mux_u_a0/B u_dll_u_div1__061_/Y
+ VPWR VGND sg13cmos5l_inv_1
Xu_dll_u_control__1731_ u_dll_u_control__1731_/Y u_dll_u_control__1300_/A u_dll_u_control__1724_/B
+ u_dll_u_control__1725_/Y u_dll_u_control__1729_/Y u_dll_u_control__1730_/Y VPWR
+ VGND sg13cmos5l_a221oi_1
Xu_dll_u_control__1800_ u_dll_u_control__2231_/D u_dll_u_control__1809_/A u_dll_u_control__1800_/B
+ VPWR VGND sg13cmos5l_nor2_1
Xu_dll_u_control__1593_ u_dll_u_control__1630_/A u_dll_u_control__1631_/A u_dll_u_control__1631_/B
+ u_dll_u_control__1576_/X VPWR VGND sg13cmos5l_a21o_1
Xu_dll_u_control__2214_ u_dll_u_control__2214_/Q u_dll_u_control__2214_/CLK u_dll_u_control__2214_/D
+ u_dll_u_control__2071_/Y VPWR VGND sg13cmos5l_dfrbpq_1
Xu_dll_u_ring_dstage\[6\].id_core_delayint0_u_inv u_dll_u_ring_dstage\[6\].id_core_delaymux1_u_a0/A
+ u_dll_u_ring_dstage\[6\].id_core_delayinv1_u_inv/Y VPWR VGND sg13cmos5l_inv_1
Xu_dll_u_control__2145_ u_dll_u_control__2145_/Q u_dll_u_control__2145_/CLK u_dll_u_control__2145_/D
+ u_dll_u_control__2002_/Y VPWR VGND sg13cmos5l_dfrbpq_1
Xu_dll_u_control__2076_ u_dll_u_control__2076_/Y u_dll_u_control__2105_/A VPWR VGND
+ sg13cmos5l_inv_1
XFILLER_24_277 VPWR VGND sg13cmos5l_fill_2
Xclkbuf_5_26__f_u_dll\_controller_ref_clk u_dll_u_control__2274_/CLK clkbuf_4_13_0_u_dll\_controller_ref_clk/X
+ VPWR VGND sg13cmos5l_buf_8
Xu_dll_u_control_fanout15 u_dll_u_control__1702_/A u_dll_u_control__1706_/A VPWR VGND
+ sg13cmos5l_buf_1
Xu_dll_u_control__1929_ u_dll_u_control__2146_/D u_dll_u_control__2320_/Q VPWR VGND
+ sg13cmos5l_buf_1
Xu_dll_u_control_fanout26 u_dll_u_control__1398_/B u_dll_u_control__1318_/X VPWR VGND
+ sg13cmos5l_buf_1
Xu_dll_u_ring_iss_core_trim_sync\[1\].applied_u_ff u_dll_u_ring_iss_core_long_gate_u_nand/B
+ u_dll_u_ring_iss_core_delayinv1_u_inv/Y u_dll_u_ring_iss_core_trim_sync\[1\].meta_u_ff/Q
+ u_dll_u_ring_iss_core_trim_reset_inv_u_inv/Y VPWR VGND sg13cmos5l_dfrbpq_1
Xu_dll_u_ring_dstage\[0\].id_core_reset_inv_u_inv u_dll_u_ring_dstage\[0\].id_core_reset_inv_u_inv/Y
+ u_dll_u_ring_dstage\[0\].id_const0_u_lo/L_LO VPWR VGND sg13cmos5l_inv_1
Xu_dll_u_control_fanout48 u_dll_u_control__1919_/B u_dll_u_control__2317_/Q VPWR VGND
+ sg13cmos5l_buf_1
Xu_dll_u_control_fanout37 u_dll_u_control__1851_/B u_dll_u_control__1885_/B VPWR VGND
+ sg13cmos5l_buf_1
Xu_dll_u_ring_dstage\[11\].id_core_delaymux1_u_sel u_dll_u_ring_dstage\[11\].id_core_delaymux1_u_a0/B
+ u_dll_u_ring_dstage\[11\].id_core_delaymux1_u_a1/B VPWR VGND sg13cmos5l_inv_1
Xu_dll_fanout80 u_dll_fanout80/X u_dll_fanout82/X VPWR VGND sg13cmos5l_buf_1
Xu_dll_u_control__1645_ u_dll_u_control__1657_/B u_dll_u_control__1616_/B u_dll_u_control__1601_/X
+ u_dll_u_control__1604_/X u_dll_u_control__1644_/Y u_dll_u_control__1702_/A VPWR
+ VGND sg13cmos5l_a221oi_1
Xu_dll_u_control__1714_ u_dll_u_control__1715_/B u_dll_u_control__2219_/Q u_dll_u_control__1714_/B
+ VPWR VGND sg13cmos5l_xnor2_1
XFILLER_44_13 VPWR VGND sg13cmos5l_fill_1
Xu_dll_u_control__1576_ u_dll_u_control__1576_/X u_dll_u_control__2138_/Q u_dll_u_control__2244_/Q
+ VPWR VGND sg13cmos5l_and2_1
XFILLER_37_380 VPWR VGND sg13cmos5l_fill_2
Xu_dll_u_ring_dstage\[2\].id_core_trim_sync\[0\].meta_u_ff u_dll_u_ring_dstage\[2\].id_core_trim_sync\[0\].meta_u_ff/Q
+ u_dll_u_ring_dstage\[2\].id_core_delayinv1_u_inv/Y u_dll_u_control__2248_/Q u_dll_u_ring_dstage\[2\].id_core_trim_reset_inv_u_inv/Y
+ VPWR VGND sg13cmos5l_dfrbpq_1
Xu_dll_u_control__2128_ u_dll_u_control__2128_/Q u_dll_u_control__2245_/CLK u_dll_u_control__2128_/D
+ u_dll_u_control__1985_/Y VPWR VGND sg13cmos5l_dfrbpq_1
Xu_dll_u_control__2059_ u_dll_u_control__2059_/Y u_dll_u_control__2060_/A VPWR VGND
+ sg13cmos5l_inv_1
XFILLER_5_29 VPWR VGND sg13cmos5l_fill_1
Xu_dll_u_ring_iss_core_short_decode_u_and u_dll_u_ring_iss_core_short_gate_u_nand/B
+ u_dll_u_ring_iss_core_delaymux1_u_a1/B u_dll_u_ring_iss_core_short_decode_u_and/B
+ VPWR VGND sg13cmos5l_and2_2
XFILLER_43_372 VPWR VGND sg13cmos5l_decap_8
XFILLER_11_291 VPWR VGND sg13cmos5l_fill_2
Xu_dll_u_control__1430_ u_dll_u_control__1438_/B u_dll_u_control__2176_/Q u_dll_u_control__2175_/Q
+ u_dll_u_control__1442_/B VPWR VGND sg13cmos5l_and3_1
XFILLER_38_166 VPWR VGND sg13cmos5l_fill_1
Xu_dll_u_control__1292_ u_dll_u_control__1705_/B u_dll_u_control__2214_/Q u_dll_u_control__2215_/Q
+ u_dll_u_control__1701_/B VPWR VGND sg13cmos5l_nand3_1
Xu_dll_u_control__1361_ u_dll_u_control__2200_/D u_dll_u_control__1384_/A u_dll_u_control__1361_/B
+ u_dll_u_control__1361_/C VPWR VGND sg13cmos5l_nor3_1
Xu_dll__36_ u_dll__36_/Y u_dll__36_/A VPWR VGND sg13cmos5l_inv_1
Xu_dll_u_control__1628_ u_dll_u_control__1643_/C u_dll_u_control__1628_/A u_dll_u_control__1628_/B
+ VPWR VGND sg13cmos5l_xnor2_1
Xu_dll_u_control__1559_ u_dll_u_control__1560_/D u_dll_u_control__1559_/A u_dll_u_control__1559_/B
+ VPWR VGND sg13cmos5l_nor2_1
XFILLER_29_144 VPWR VGND sg13cmos5l_fill_1
XFILLER_4_232 VPWR VGND sg13cmos5l_decap_8
Xu_dll_u_ring_dstage\[11\].id_core_reset_inv_u_inv u_dll_u_ring_dstage\[11\].id_core_reset_inv_u_inv/Y
+ u_dll_u_ring_dstage\[11\].id_const0_u_lo/L_LO VPWR VGND sg13cmos5l_inv_1
Xu_dll_u_ring_dstage\[11\].id_core_trim_sync\[0\].meta_u_ff u_dll_u_ring_dstage\[11\].id_core_trim_sync\[0\].meta_u_ff/Q
+ u_dll_u_ring_dstage\[11\].id_core_delayinv1_u_inv/Y u_dll_u_control__2257_/Q u_dll_u_ring_dstage\[11\].id_core_trim_reset_inv_u_inv/Y
+ VPWR VGND sg13cmos5l_dfrbpq_1
XFILLER_35_169 VPWR VGND sg13cmos5l_decap_8
XFILLER_35_136 VPWR VGND sg13cmos5l_fill_2
XFILLER_29_90 VPWR VGND sg13cmos5l_fill_1
XFILLER_16_372 VPWR VGND sg13cmos5l_fill_1
Xu_dll_u_control__1413_ u_dll_u_control__1417_/A u_dll_u_control__2294_/Q u_dll_u_control__2300_/Q
+ VPWR VGND sg13cmos5l_xor2_1
Xu_dll_u_div1_u_bypass_mux_u_a0 u_dll_u_div1_u_bypass_mux_u_a0/Y u_dll_u_div1_u_bypass_mux_u_a0/A
+ u_dll_u_div1_u_bypass_mux_u_a0/B VPWR VGND sg13cmos5l_nand2_2
Xu_dll_u_control__1275_ u_dll_u_control__1863_/B u_dll_u_control__1851_/A u_dll_u_control__1851_/B
+ VPWR VGND sg13cmos5l_nand2_1
Xu_dll_u_control__1344_ u_dll_u_control__1345_/C u_dll_u_control__2203_/Q u_dll_u_control__1924_/A1
+ VPWR VGND sg13cmos5l_nor2b_1
XFILLER_22_331 VPWR VGND sg13cmos5l_decap_8
Xu_dll__19_ u_dll__19_/X u_dll__26_/A u_dll__26_/B VPWR VGND sg13cmos5l_and2_1
XFILLER_1_279 VPWR VGND sg13cmos5l_fill_2
XFILLER_40_161 VPWR VGND sg13cmos5l_fill_1
XFILLER_13_375 VPWR VGND sg13cmos5l_fill_1
XFILLER_0_290 VPWR VGND sg13cmos5l_fill_2
Xu_dll_u_div1__087_ u_dll_u_div1__088_/B u_dll_u_div1__105_/Q u_dll_u_div1__087_/B
+ VPWR VGND sg13cmos5l_xor2_1
Xu_dll_u_control__1962_ u_dll_u_control__1962_/Y u_dll_u_control__2049_/A VPWR VGND
+ sg13cmos5l_inv_1
Xu_dll_u_control__1893_ u_dll_u_control__2292_/D u_dll_u_control__1898_/A u_dll_u_control__2288_/Q
+ VPWR VGND sg13cmos5l_and2_1
XFILLER_36_14 VPWR VGND sg13cmos5l_decap_8
Xu_dll_u_ring_dstage\[10\].id_core_delaybuf1_u_buf u_dll_u_ring_dstage\[10\].id_core_delayinv1_u_inv/A
+ u_dll_u_ring_dstage\[10\].id_core_delaymux1_u_a1/A VPWR VGND sg13cmos5l_buf_1
Xu_dll_u_control__1258_ u_dll_u_control__1258_/Y u_dll_u_control__1143_/Y u_dll_u_control__1260_/S
+ VPWR VGND sg13cmos5l_nand2b_1
Xu_dll_u_control__1189_ u_dll_u_control__1190_/A u_dll_u_control__1189_/A u_dll_u_control__1189_/B
+ VPWR VGND sg13cmos5l_xnor2_1
Xu_dll_u_control__1327_ u_dll_u_control__1327_/Y u_dll_u_control__1386_/A u_dll_u_control__1392_/B
+ VPWR VGND sg13cmos5l_nand2b_1
Xu_dll_u_ring_dstage\[5\].id_core_short_decode_u_and u_dll_u_ring_dstage\[5\].id_core_short_gate_u_nand/B
+ u_dll_u_ring_dstage\[5\].id_core_delaymux1_u_a1/B u_dll_u_ring_dstage\[5\].id_core_short_decode_u_and/B
+ VPWR VGND sg13cmos5l_and2_2
Xu_dll_u_control__2230_ u_dll_u_control__2230_/Q clkload3/A u_dll_u_control__2230_/D
+ u_dll_u_control__2087_/Y VPWR VGND sg13cmos5l_dfrbpq_1
Xu_dll_u_control__1112_ u_dll_u_control__1112_/X u_dll_u_control__2134_/Q u_dll_u_control__2274_/Q
+ VPWR VGND sg13cmos5l_and2_1
Xclkbuf_4_5__f_u_dll\_controller_ring_clk u_dll_u_control__2185_/CLK clkbuf_3_2_0_u_dll\_controller_ring_clk/X
+ VPWR VGND sg13cmos5l_buf_8
Xu_dll_u_control__2161_ u_dll_u_control__2161_/Q u_dll_u_control__2161_/CLK u_dll_u_control__2161_/D
+ u_dll_u_control__2018_/Y VPWR VGND sg13cmos5l_dfrbpq_1
Xu_dll_u_control__2092_ u_dll_u_control__2092_/Y u_dll_u_control__2093_/A VPWR VGND
+ sg13cmos5l_inv_1
Xu_dll_u_control__1945_ u_dll_u_control__1945_/Y u_dll_u_control__2119_/A VPWR VGND
+ sg13cmos5l_inv_1
Xu_dll_u_control__1876_ u_dll_u_control__2275_/D u_dll_u_control__1876_/A u_dll_u_control__1876_/B
+ VPWR VGND sg13cmos5l_nor2_1
Xu_dll_u_ring_dstage\[5\].id_core_trim_sync\[1\].applied_u_ff u_dll_u_ring_dstage\[5\].id_core_long_gate_u_nand/B
+ u_dll_u_ring_dstage\[5\].id_core_delayinv1_u_inv/Y u_dll_u_ring_dstage\[5\].id_core_trim_sync\[1\].meta_u_ff/Q
+ u_dll_u_ring_dstage\[5\].id_core_trim_reset_inv_u_inv/Y VPWR VGND sg13cmos5l_dfrbpq_1
Xu_dll_u_div0__088_ u_dll_u_div0__105_/D u_dll_u_div0__088_/A u_dll_u_div0__088_/B
+ VPWR VGND sg13cmos5l_nor2_1
Xu_dll_u_ring_dstage\[7\].id_core_delayinv1_u_inv u_dll_u_ring_dstage\[7\].id_core_delayinv1_u_inv/Y
+ u_dll_u_ring_dstage\[7\].id_core_delayinv1_u_inv/A VPWR VGND sg13cmos5l_inv_2
XFILLER_33_201 VPWR VGND sg13cmos5l_fill_2
XFILLER_18_297 VPWR VGND sg13cmos5l_decap_4
Xu_dll_u_control__1661_ u_dll_u_control__1661_/Y u_dll_u_control__1661_/A u_dll_u_control__1661_/B
+ u_dll_u_control__1663_/C VPWR VGND sg13cmos5l_nor3_1
Xu_dll_u_control__1592_ u_dll_u_control__1631_/B u_dll_u_control__2138_/Q u_dll_u_control__2244_/Q
+ VPWR VGND sg13cmos5l_xor2_1
Xu_dll_u_control__1730_ u_dll_u_control__1730_/Y u_dll_u_control__1926_/A u_dll_u_control__1730_/B
+ VPWR VGND sg13cmos5l_nor2_1
Xu_dll_u_control__2213_ u_dll_u_control__2213_/Q u_dll_u_control__2280_/CLK u_dll_u_control__2213_/D
+ u_dll_u_control__2070_/Y VPWR VGND sg13cmos5l_dfrbpq_1
XFILLER_17_38 VPWR VGND sg13cmos5l_fill_2
Xu_dll_u_control__2144_ u_dll_u_control__2144_/Q clkload6/A u_dll_u_control__2144_/D
+ u_dll_u_control__2001_/Y VPWR VGND sg13cmos5l_dfrbpq_1
Xu_dll_u_control__2075_ u_dll_u_control__2075_/Y u_dll_u_control__2077_/A VPWR VGND
+ sg13cmos5l_inv_1
Xu_dll_u_control__1928_ u_dll_u_control__2147_/D u_dll_u_control__2321_/Q VPWR VGND
+ sg13cmos5l_buf_1
Xu_dll_u_control_fanout38 u_dll_u_control__1885_/B u_dll_u_control__1878_/B VPWR VGND
+ sg13cmos5l_buf_1
Xu_dll_u_control_fanout27 u_dll_u_control__1896_/A u_dll_u_control__1921_/B VPWR VGND
+ sg13cmos5l_buf_1
Xu_dll_u_control_fanout16 u_dll_u_control__1506_/B u_dll_u_control__1467_/X VPWR VGND
+ sg13cmos5l_buf_1
Xu_dll_u_control_fanout49 u_dll_u_control__1797_/B u_dll_u_control__1814_/A VPWR VGND
+ sg13cmos5l_buf_1
XFILLER_47_326 VPWR VGND sg13cmos5l_fill_1
Xu_dll_u_control__1859_ u_dll_u_control__1859_/Y u_dll_u_control__1859_/A u_dll_u_control__1859_/B
+ u_dll_u_control__1859_/C VPWR VGND sg13cmos5l_nor3_1
XFILLER_15_245 VPWR VGND sg13cmos5l_decap_8
XFILLER_15_278 VPWR VGND sg13cmos5l_decap_4
XFILLER_30_248 VPWR VGND sg13cmos5l_fill_1
XFILLER_23_92 VPWR VGND sg13cmos5l_fill_2
XFILLER_46_392 VPWR VGND sg13cmos5l_decap_8
XFILLER_17_4 VPWR VGND sg13cmos5l_fill_2
Xu_dll_u_control__1575_ u_dll_u_control__1575_/X u_dll_u_control__2139_/Q u_dll_u_control__1629_/B
+ VPWR VGND sg13cmos5l_and2_1
Xu_dll_u_control__1644_ u_dll_u_control__1644_/Y u_dll_u_control__1649_/B u_dll_u_control__1647_/B
+ u_dll_u_control__1644_/C VPWR VGND sg13cmos5l_nand3_1
Xu_dll_u_control__1713_ u_dll_u_control__2218_/D u_dll_u_control__1713_/A u_dll_u_control__1713_/B
+ VPWR VGND sg13cmos5l_nor2_1
XFILLER_29_359 VPWR VGND sg13cmos5l_fill_2
XFILLER_28_59 VPWR VGND sg13cmos5l_fill_1
Xu_dll_u_ring_dstage\[2\].id_const0_u_lo u_dll_u_ring_dstage\[2\].id_const0_u_lo/L_LO
+ VPWR VGND sg13cmos5l_tielo
XFILLER_44_69 VPWR VGND sg13cmos5l_decap_4
Xu_dll_u_control__2127_ u_dll_u_control__2127_/Y u_dll_u_control__2127_/A VPWR VGND
+ sg13cmos5l_inv_1
Xu_dll_u_control__2058_ u_dll_u_control__2058_/Y u_dll_u_control__2064_/A VPWR VGND
+ sg13cmos5l_inv_1
XFILLER_43_362 VPWR VGND sg13cmos5l_decap_4
XFILLER_38_189 VPWR VGND sg13cmos5l_decap_4
Xu_dll_u_control__1291_ u_dll_u_control__1703_/B u_dll_u_control__2214_/Q u_dll_u_control__1701_/B
+ VPWR VGND sg13cmos5l_nand2_1
Xu_dll_u_control__1360_ u_dll_u_control__1361_/C u_dll_u_control__2200_/Q u_dll_u_control__1371_/A
+ VPWR VGND sg13cmos5l_nor2b_1
Xu_dll__35_ u_dll__35_/Y u_dll__36_/A VPWR VGND sg13cmos5l_inv_1
Xu_dll_u_control__1627_ u_dll_u_control__1643_/B u_dll_u_control__1627_/A u_dll_u_control__1627_/B
+ VPWR VGND sg13cmos5l_xnor2_1
Xu_dll_u_control__1558_ u_dll_u_control__1559_/B u_dll_u_control__1130_/Y u_dll_u_control__1557_/Y
+ u_dll_u_control__1099_/A VPWR VGND sg13cmos5l_a21oi_1
XFILLER_29_178 VPWR VGND sg13cmos5l_decap_4
Xu_dll_u_control__1489_ u_dll_u_control__1490_/C u_dll_u_control__2159_/Q u_dll_u_control__1507_/B
+ VPWR VGND sg13cmos5l_nor2_1
XFILLER_44_159 VPWR VGND sg13cmos5l_fill_1
XFILLER_40_321 VPWR VGND sg13cmos5l_decap_4
XFILLER_4_211 VPWR VGND sg13cmos5l_decap_8
XFILLER_4_288 VPWR VGND sg13cmos5l_decap_8
XFILLER_20_82 VPWR VGND sg13cmos5l_fill_1
XFILLER_16_351 VPWR VGND sg13cmos5l_fill_1
XFILLER_31_343 VPWR VGND sg13cmos5l_decap_8
Xu_dll_u_ring_dstage\[1\].id_core_delaymux1_u_a0 u_dll_u_ring_dstage\[1\].id_core_delaymux1_u_a0/Y
+ u_dll_u_ring_dstage\[1\].id_core_delaymux1_u_a0/A u_dll_u_ring_dstage\[1\].id_core_delaymux1_u_a0/B
+ VPWR VGND sg13cmos5l_nand2_2
Xu_dll_u_control__1343_ u_dll_u_control__1345_/B u_dll_u_control__1338_/B u_dll_u_control__1342_/Y
+ u_dll_u_control__1924_/A1 VPWR VGND sg13cmos5l_a21oi_1
Xu_dll_u_control__1412_ u_dll_u_control__2180_/D u_dll_u_control__1896_/A u_dll_u_control__2314_/Q
+ VPWR VGND sg13cmos5l_and2_1
XFILLER_26_104 VPWR VGND sg13cmos5l_decap_4
Xu_dll_u_div1_u_bypass_mux_u_a1 u_dll_u_div1_u_bypass_mux_u_a1/Y u_dll_u_div1_buffer_u_buf/X
+ u_dll_u_div1__061_/Y VPWR VGND sg13cmos5l_nand2_2
Xu_dll_u_control__1274_ u_dll_u_control__2262_/D u_dll_u_control__1238_/A u_dll_u_control__1859_/C
+ u_dll_u_control__1860_/A VPWR VGND sg13cmos5l_a21oi_1
XFILLER_22_310 VPWR VGND sg13cmos5l_decap_8
Xu_dll__18_ u_dll__18_/Y u_dll__36_/A VPWR VGND sg13cmos5l_inv_1
XFILLER_22_387 VPWR VGND sg13cmos5l_decap_8
XFILLER_45_402 VPWR VGND sg13cmos5l_fill_2
XFILLER_9_347 VPWR VGND sg13cmos5l_fill_2
Xu_dll_u_ring_dstage\[6\].id_core_trim_reset_inv_u_inv u_dll_u_ring_dstage\[6\].id_core_trim_reset_inv_u_inv/Y
+ u_dll_u_ring_trim_reset_buffers\[2\].u_buffer_u_buf/X VPWR VGND sg13cmos5l_inv_2
XFILLER_13_321 VPWR VGND sg13cmos5l_decap_4
Xu_dll_u_ring_iss_core_delaybuf1_u_buf u_dll_u_ring_iss_core_delayinv1_u_inv/A u_dll_u_ring_iss_core_delaymux1_u_a1/A
+ VPWR VGND sg13cmos5l_buf_1
Xu_dll_u_div1__086_ u_dll_u_div1__104_/D u_dll_u_div1__088_/A u_dll_u_div1__086_/B
+ VPWR VGND sg13cmos5l_nor2_1
XFILLER_36_402 VPWR VGND sg13cmos5l_fill_2
XFILLER_31_140 VPWR VGND sg13cmos5l_fill_2
XFILLER_31_195 VPWR VGND sg13cmos5l_fill_2
XFILLER_31_173 VPWR VGND sg13cmos5l_decap_8
Xu_dll_u_control__1961_ u_dll_u_control__1961_/Y u_dll_u_control__2023_/A VPWR VGND
+ sg13cmos5l_inv_1
Xu_dll_u_ring_dstage\[7\].id_const0_u_lo u_dll_u_ring_dstage\[7\].id_const0_u_lo/L_LO
+ VPWR VGND sg13cmos5l_tielo
Xu_dll_u_control__1892_ u_dll_u_control__2291_/D u_dll_u_control__1896_/A u_dll_u_control__2287_/Q
+ VPWR VGND sg13cmos5l_and2_1
Xu_dll_u_control__1326_ u_dll_u_control__1326_/Y u_dll_u_control__2206_/Q u_dll_u_control__1386_/A
+ u_dll_u_control__1392_/B VPWR VGND sg13cmos5l_nand3_1
Xu_dll_u_control__1257_ u_dll_u_control__1260_/S u_dll_u_control__2286_/Q u_dll_u_control__1170_/B
+ u_dll_u_control__1169_/Y u_dll_u_control__1172_/Y u_dll_u_control__1204_/X VPWR
+ VGND sg13cmos5l_a221oi_1
Xu_dll_u_control__1188_ u_dll_u_control__1188_/Y u_dll_u_control__2281_/Q u_dll_u_control__1153_/Y
+ u_dll_u_control__1243_/A u_dll_u_control__1191_/A VPWR VGND sg13cmos5l_a22oi_1
XFILLER_26_92 VPWR VGND sg13cmos5l_decap_4
XFILLER_42_91 VPWR VGND sg13cmos5l_decap_8
Xu_dll_u_div1__069_ u_dll_u_div1__071_/B u_dll_u_div1__085_/A u_dll_u_div1__072_/B
+ u_dll_u_div1__069_/C VPWR VGND sg13cmos5l_nor3_1
XFILLER_36_210 VPWR VGND sg13cmos5l_fill_2
XFILLER_3_96 VPWR VGND sg13cmos5l_fill_1
Xu_dll_u_control__2160_ u_dll_u_control__2160_/Q clkload2/A u_dll_u_control__2160_/D
+ u_dll_u_control__2017_/Y VPWR VGND sg13cmos5l_dfrbpq_1
Xu_dll_u_control__1111_ u_dll_u_control__1120_/B u_dll_u_control__2135_/Q u_dll_u_control__2275_/Q
+ VPWR VGND sg13cmos5l_nor2_1
Xu_dll_u_ring_dstage\[0\].id_core_trim_sync\[1\].applied_u_ff u_dll_u_ring_dstage\[0\].id_core_long_gate_u_nand/B
+ u_dll_u_ring_dstage\[0\].id_core_delayinv1_u_inv/Y u_dll_u_ring_dstage\[0\].id_core_trim_sync\[1\].meta_u_ff/Q
+ u_dll_u_ring_dstage\[0\].id_core_trim_reset_inv_u_inv/Y VPWR VGND sg13cmos5l_dfrbpq_1
Xu_dll_u_control__2091_ u_dll_u_control__2091_/Y u_dll_u_control__2093_/A VPWR VGND
+ sg13cmos5l_inv_1
Xu_dll_u_control__1875_ u_dll_u_control__1876_/B u_dll_u_control__1875_/A u_dll_u_control__1875_/B
+ VPWR VGND sg13cmos5l_xnor2_1
Xu_dll_u_control__1944_ u_dll_u_control__1944_/Y u_dll_u_control__2119_/A VPWR VGND
+ sg13cmos5l_inv_1
XFILLER_42_279 VPWR VGND sg13cmos5l_fill_1
Xu_dll_u_control__1309_ u_dll_u_control__1310_/C u_dll_u_control__2312_/Q u_dll_u_control__1309_/B
+ u_dll_u_control__1309_/C u_dll_u_control__1309_/D VPWR VGND sg13cmos5l_nand4_1
XFILLER_27_298 VPWR VGND sg13cmos5l_fill_2
Xu_dll_u_control__2289_ u_dll_u_control__2289_/Q u_dll_u_control__2299_/CLK u_dll_u_control__2289_/D
+ u_dll_u_control__1949_/Y VPWR VGND sg13cmos5l_dfrbpq_1
Xu_dll_u_ring_dstage\[10\].id_core_short_gate_u_nand u_dll_u_ring_dstage\[10\].id_core_short_gate_u_nand/Y
+ u_dll_u_ring_dstage\[9\].id_core_reset_gate_u_aoi/Y u_dll_u_ring_dstage\[10\].id_core_short_gate_u_nand/B
+ VPWR VGND sg13cmos5l_nand2_1
Xu_dll_u_div0__087_ u_dll_u_div0__088_/B u_dll_u_div0__105_/Q u_dll_u_div0__087_/B
+ VPWR VGND sg13cmos5l_xor2_1
XFILLER_5_0 VPWR VGND sg13cmos5l_fill_2
XFILLER_18_232 VPWR VGND sg13cmos5l_decap_4
Xu_dll_u_control__1660_ u_dll_u_control__2139_/D u_dll_u_control__2139_/Q u_dll_u_control__1661_/A
+ u_dll_u_control__1659_/Y VPWR VGND sg13cmos5l_a21o_1
Xu_dll_u_control__1591_ u_dll_u_control__1631_/A u_dll_u_control__1632_/A u_dll_u_control__1632_/B
+ u_dll_u_control__1577_/Y VPWR VGND sg13cmos5l_o21ai_1
XFILLER_38_0 VPWR VGND sg13cmos5l_fill_2
XFILLER_49_390 VPWR VGND sg13cmos5l_decap_8
Xu_dll_u_control__2143_ u_dll_u_control__2143_/Q u_dll_u_control__2145_/CLK u_dll_u_control__2143_/D
+ u_dll_u_control__2000_/Y VPWR VGND sg13cmos5l_dfrbpq_1
Xu_dll_u_control__2212_ u_dll_u_control__2212_/Q u_dll_u_control__2214_/CLK u_dll_u_control__2212_/D
+ u_dll_u_control__2069_/Y VPWR VGND sg13cmos5l_dfrbpq_1
Xu_dll_u_control__2074_ u_dll_u_control__2074_/Y u_dll_u_control__2118_/A VPWR VGND
+ sg13cmos5l_inv_1
Xu_dll_u_control_fanout39 u_dll_u_control__1878_/B u_dll_u_control__1225_/X VPWR VGND
+ sg13cmos5l_buf_1
Xu_dll_u_control__1927_ u_dll_u_control__2148_/D u_dll_u_control__2322_/Q VPWR VGND
+ sg13cmos5l_buf_1
Xu_dll_u_control_fanout28 u_dll_u_control__1921_/B u_dll_u_control__2319_/Q VPWR VGND
+ sg13cmos5l_buf_1
Xu_dll_u_ring_dstage\[9\].id_core_delaybuf1_u_buf u_dll_u_ring_dstage\[9\].id_core_delayinv1_u_inv/A
+ u_dll_u_ring_dstage\[9\].id_core_delaymux1_u_a1/A VPWR VGND sg13cmos5l_buf_1
Xu_dll_u_control_fanout17 u_dll_u_control__1485_/B u_dll_u_control__1467_/X VPWR VGND
+ sg13cmos5l_buf_1
Xu_dll_u_control__1858_ u_dll_u_control__2249_/D u_dll_u_control__1858_/A u_dll_u_control__1858_/B
+ u_dll_u_control__1858_/C VPWR VGND sg13cmos5l_nor3_1
XFILLER_47_338 VPWR VGND sg13cmos5l_fill_1
Xu_dll_u_control__1789_ u_dll_u_control__2245_/D u_dll_u_control__1809_/A u_dll_u_control__1789_/B
+ u_dll_u_control__1789_/C VPWR VGND sg13cmos5l_nor3_1
XFILLER_15_213 VPWR VGND sg13cmos5l_fill_1
Xu_dll_fanout82 u_dll_fanout82/X u_dll__20_/Y VPWR VGND sg13cmos5l_buf_1
XFILLER_46_371 VPWR VGND sg13cmos5l_decap_8
Xu_dll_u_ring_dstage\[11\].id_core_fast_decode_u_nor u_dll_u_ring_dstage\[11\].id_core_reset_gate_u_aoi/A2
+ u_dll_u_ring_dstage\[11\].id_core_delaymux1_u_a1/B u_dll_u_ring_dstage\[11\].id_core_long_gate_u_nand/B
+ VPWR VGND sg13cmos5l_nor2_2
Xu_dll_u_control__1712_ u_dll_u_control__1713_/B u_dll_u_control__1715_/A u_dll_u_control__1710_/Y
+ u_dll_u_control__1711_/Y u_dll_u_control__1719_/B VPWR VGND sg13cmos5l_a22oi_1
Xu_dll_u_control__1574_ u_dll_u_control__1574_/X u_dll_u_control__2139_/Q u_dll_u_control__1629_/B
+ VPWR VGND sg13cmos5l_or2_1
Xu_dll_u_control__1643_ u_dll_u_control__1644_/C u_dll_u_control__1643_/A u_dll_u_control__1643_/B
+ u_dll_u_control__1643_/C u_dll_u_control__1643_/D VPWR VGND sg13cmos5l_nand4_1
Xu_dll_u_control__2126_ u_dll_u_control__2126_/Y u_dll_fanout80/X VPWR VGND sg13cmos5l_inv_1
Xu_dll_u_control__2057_ u_dll_u_control__2057_/Y u_dll_u_control__2064_/A VPWR VGND
+ sg13cmos5l_inv_1
Xu_dll_u_ring_dstage\[0\].id_core_reset_gate_u_aoi u_dll_u_ring_dstage\[0\].id_core_reset_gate_u_aoi/Y
+ u_dll_u_ring_u_output_inv0_u_inv/A u_dll_u_ring_dstage\[0\].id_core_reset_gate_u_aoi/A2
+ u_dll_u_ring_dstage\[0\].id_core_reset_gate_u_aoi/B1 VPWR VGND sg13cmos5l_a21oi_2
XFILLER_43_341 VPWR VGND sg13cmos5l_fill_1
XFILLER_18_93 VPWR VGND sg13cmos5l_fill_2
XFILLER_7_231 VPWR VGND sg13cmos5l_decap_4
XFILLER_11_293 VPWR VGND sg13cmos5l_fill_1
XFILLER_38_146 VPWR VGND sg13cmos5l_decap_4
XFILLER_46_190 VPWR VGND sg13cmos5l_fill_1
Xu_dll_u_control__1290_ u_dll_u_control__1701_/B u_dll_u_control__2213_/Q u_dll_u_control__1699_/B
+ VPWR VGND sg13cmos5l_and2_1
XFILLER_34_341 VPWR VGND sg13cmos5l_fill_2
XFILLER_34_330 VPWR VGND sg13cmos5l_fill_1
Xu_dll__34_ u_dll__34_/Y u_dll__36_/A VPWR VGND sg13cmos5l_inv_1
Xu_dll_u_control__1626_ u_dll_u_control__1627_/B u_dll_u_control__1596_/A u_dll_u_control__1628_/B
+ u_dll_u_control__1571_/Y VPWR VGND sg13cmos5l_o21ai_1
Xu_dll_u_control__1557_ u_dll_u_control__1557_/Y u_dll_u_control__1618_/A u_dll_u_control__2143_/Q
+ u_dll_u_control__2142_/Q VPWR VGND sg13cmos5l_nor3_1
XFILLER_29_113 VPWR VGND sg13cmos5l_fill_2
Xu_dll_u_control__1488_ u_dll_u_control__1490_/B u_dll_u_control__2187_/Q u_dll_u_control__1506_/B
+ VPWR VGND sg13cmos5l_nor2_1
Xu_dll_u_control__2109_ u_dll_u_control__2109_/Y u_dll_u_control__2118_/A VPWR VGND
+ sg13cmos5l_inv_1
XFILLER_4_267 VPWR VGND sg13cmos5l_decap_8
Xclkbuf_5_0__f_u_dll\_controller_ref_clk u_dll_u_control__2308_/CLK clkbuf_4_0_0_u_dll\_controller_ref_clk/X
+ VPWR VGND sg13cmos5l_buf_8
XFILLER_35_138 VPWR VGND sg13cmos5l_fill_1
Xu_dll_u_ring_dstage\[9\].id_core_trim_sync\[0\].applied_u_ff u_dll_u_ring_dstage\[9\].id_core_delaymux1_u_a1/B
+ u_dll_u_ring_dstage\[9\].id_core_delayinv1_u_inv/Y u_dll_u_ring_dstage\[9\].id_core_trim_sync\[0\].meta_u_ff/Q
+ u_dll_u_ring_dstage\[9\].id_core_trim_reset_inv_u_inv/Y VPWR VGND sg13cmos5l_dfrbpq_1
Xu_dll_u_ring_dstage\[1\].id_core_delaymux1_u_a1 u_dll_u_ring_dstage\[1\].id_core_delaymux1_u_a1/Y
+ u_dll_u_ring_dstage\[1\].id_core_delaymux1_u_a1/A u_dll_u_ring_dstage\[1\].id_core_delaymux1_u_a1/B
+ VPWR VGND sg13cmos5l_nand2_2
Xu_dll_u_control__1342_ u_dll_u_control__1342_/Y u_dll_u_control__2203_/Q u_dll_u_control__1342_/B
+ VPWR VGND sg13cmos5l_nand2b_1
Xu_dll_u_control__1411_ u_dll_u_control__2181_/D u_dll_u_control__1384_/B u_dll_u_control__1386_/C
+ u_dll_u_control__1410_/Y VPWR VGND sg13cmos5l_o21ai_1
Xu_dll_u_control__1273_ u_dll_u_control__1859_/C u_dll_u_control__1834_/B u_dll_u_control__1827_/B
+ VPWR VGND sg13cmos5l_nand2_1
XFILLER_22_366 VPWR VGND sg13cmos5l_decap_8
Xu_dll_u_control__1609_ u_dll_u_control__1610_/D u_dll_u_control__2159_/Q u_dll_u_control__2158_/Q
+ u_dll_u_control__2157_/Q u_dll_u_control__2156_/Q VPWR VGND sg13cmos5l_nor4_1
XFILLER_9_304 VPWR VGND sg13cmos5l_decap_8
XFILLER_9_326 VPWR VGND sg13cmos5l_decap_8
Xu_dll_u_div1__085_ u_dll_u_div1__086_/B u_dll_u_div1__085_/A u_dll_u_div1__085_/B
+ VPWR VGND sg13cmos5l_xnor2_1
Xu_dll_u_div0_u_clkbuf_count_u_buf u_dll_u_div0__056_/A u_dll_u_div0_buffer_u_buf/X
+ VPWR VGND sg13cmos5l_buf_4
Xu_dll_u_control__1960_ u_dll_u_control__1960_/Y u_dll_u_control__2034_/A VPWR VGND
+ sg13cmos5l_inv_1
Xu_dll_u_control__1891_ u_dll_u_control__2300_/D u_dll_u_control__1898_/A u_dll_u_control__2294_/Q
+ VPWR VGND sg13cmos5l_and2_1
Xu_dll_u_div0_fanout59 u_dll_u_div0_fanout59/X u_dll_fanout61/X VPWR VGND sg13cmos5l_buf_1
Xu_dll_u_control__1325_ u_dll_u_control__2207_/D u_dll_u_control__1382_/A u_dll_u_control__1325_/A2
+ u_dll_u_control__1324_/Y VPWR VGND sg13cmos5l_o21ai_1
Xu_dll_u_control__1256_ u_dll_u_control__2261_/D u_dll_u_control__1262_/B u_dll_u_control__1256_/B
+ VPWR VGND sg13cmos5l_nor2_1
Xu_dll_u_control__1187_ u_dll_u_control__1187_/Y u_dll_u_control__1243_/A VPWR VGND
+ sg13cmos5l_inv_1
XFILLER_10_369 VPWR VGND sg13cmos5l_decap_4
Xu_dll_u_ring_dstage\[10\].id_core_delayint0_u_inv u_dll_u_ring_dstage\[10\].id_core_delaymux1_u_a0/A
+ u_dll_u_ring_dstage\[10\].id_core_delayinv1_u_inv/Y VPWR VGND sg13cmos5l_inv_1
XFILLER_3_64 VPWR VGND sg13cmos5l_decap_4
Xu_dll_u_control__1110_ u_dll_u_control__1120_/A u_dll_u_control__2136_/Q u_dll_u_control__2276_/Q
+ VPWR VGND sg13cmos5l_xnor2_1
Xu_dll_u_div1__068_ u_dll_u_div1__069_/C u_dll_u_div1__062_/A u_dll_u_div1__062_/B
+ u_dll_u_div1__050_/Y VPWR VGND sg13cmos5l_a21oi_1
XFILLER_36_266 VPWR VGND sg13cmos5l_fill_1
Xu_dll_u_control__2090_ u_dll_u_control__2090_/Y u_dll_u_control__2090_/A VPWR VGND
+ sg13cmos5l_inv_1
Xu_dll_u_ring_dstage\[2\].id_core_secondary_inv_u_inv u_dll_u_ring_dstage\[2\].id_core_short_decode_u_and/B
+ u_dll_u_ring_dstage\[2\].id_core_long_gate_u_nand/B VPWR VGND sg13cmos5l_inv_1
Xu_dll_u_control__1874_ u_dll_u_control__1875_/B u_dll_u_control__2135_/Q u_dll_u_control__2275_/Q
+ VPWR VGND sg13cmos5l_xnor2_1
Xu_dll_u_control__1943_ u_dll_u_control__1943_/Y u_dll_u_control__2119_/A VPWR VGND
+ sg13cmos5l_inv_1
Xclkbuf_5_11__f_u_dll\_controller_ref_clk u_dll_u_control__2322_/CLK clkbuf_4_5_0_u_dll\_controller_ref_clk/X
+ VPWR VGND sg13cmos5l_buf_8
XFILLER_47_48 VPWR VGND sg13cmos5l_fill_1
XFILLER_42_269 VPWR VGND sg13cmos5l_decap_8
XFILLER_42_203 VPWR VGND sg13cmos5l_fill_1
Xu_dll_u_control__1308_ u_dll_u_control__1309_/D u_dll_u_control__1083_/Y u_dll_u_control__1925_/A
+ u_dll_u_control__2148_/Q u_dll_u_control__1300_/A u_dll_u_control__1305_/X VPWR
+ VGND sg13cmos5l_a221oi_1
Xu_dll_u_control__1239_ u_dll_u_control__2270_/D u_dll_u_control__1285_/A VPWR VGND
+ sg13cmos5l_inv_1
Xu_dll_u_control__2288_ u_dll_u_control__2288_/Q u_dll_u_control__2298_/CLK u_dll_u_control__2288_/D
+ u_dll_u_control__1948_/Y VPWR VGND sg13cmos5l_dfrbpq_1
Xu_dll_u_div0__086_ u_dll_u_div0__104_/D u_dll_u_div0__088_/A u_dll_u_div0__086_/B
+ VPWR VGND sg13cmos5l_nor2_1
XFILLER_33_203 VPWR VGND sg13cmos5l_fill_1
Xu_dll_u_ring_u_output_inv1_u_inv u_dll_u_ring_u_clkbuf_u_buf/A u_dll_u_ring_u_output_inv1_u_inv/A
+ VPWR VGND sg13cmos5l_inv_4
Xu_dll_u_div1_u_parity_mux_u_merge u_dll_u_div1_u_valid_gate_u_and/A u_dll_u_div1_u_parity_mux_u_a0/Y
+ u_dll_u_div1_u_parity_mux_u_a1/Y VPWR VGND sg13cmos5l_nand2_2
Xu_dll_u_control__1590_ u_dll_u_control__1632_/B u_dll_u_control__2137_/Q u_dll_u_control__2243_/Q
+ VPWR VGND sg13cmos5l_xnor2_1
Xu_dll_u_control__2142_ u_dll_u_control__2142_/Q u_dll_u_control__2145_/CLK u_dll_u_control__2142_/D
+ u_dll_u_control__1999_/Y VPWR VGND sg13cmos5l_dfrbpq_1
Xu_dll_u_control__2211_ u_dll_u_control__2211_/Q u_dll_u_control__2214_/CLK u_dll_u_control__2211_/D
+ u_dll_u_control__2068_/Y VPWR VGND sg13cmos5l_dfrbpq_1
XFILLER_33_39 VPWR VGND sg13cmos5l_decap_4
Xu_dll_u_control__2073_ u_dll_u_control__2073_/Y u_dll_u_control__2077_/A VPWR VGND
+ sg13cmos5l_inv_1
Xu_dll_u_control_fanout29 u_dll_u_control__1898_/A u_dll_u_control__2319_/Q VPWR VGND
+ sg13cmos5l_buf_1
Xu_dll_u_control_fanout18 u_dll_u_control__1507_/B u_dll_u_control__1466_/Y VPWR VGND
+ sg13cmos5l_buf_1
Xu_dll_u_control__1788_ u_dll_u_control__1789_/C u_dll_u_control__1788_/A u_dll_u_control__1788_/B
+ u_dll_u_control__1788_/C VPWR VGND sg13cmos5l_nor3_1
Xu_dll_u_control__1926_ u_dll_u_control__2149_/D u_dll_u_control__1926_/A VPWR VGND
+ sg13cmos5l_buf_1
Xu_dll_u_control__1857_ u_dll_u_control__1858_/C u_dll_u_control__1857_/A u_dll_u_control__1859_/B
+ u_dll_u_control__1860_/B VPWR VGND sg13cmos5l_nor3_1
Xu_dll_u_div0__069_ u_dll_u_div0__071_/B u_dll_u_div0__085_/A u_dll_u_div0__072_/B
+ u_dll_u_div0__069_/C VPWR VGND sg13cmos5l_nor3_1
Xu_dll_fanout61 u_dll_fanout61/X u_dll__29_/X VPWR VGND sg13cmos5l_buf_1
XFILLER_23_83 VPWR VGND sg13cmos5l_decap_4
XFILLER_0_21 VPWR VGND sg13cmos5l_decap_4
XFILLER_0_43 VPWR VGND sg13cmos5l_decap_4
Xu_dll_u_control__1642_ u_dll_u_control__1643_/D u_dll_u_control__1659_/B u_dll_u_control__1661_/B
+ u_dll_u_control__1663_/B u_dll_u_control__1642_/D VPWR VGND sg13cmos5l_nand4_1
Xu_dll_u_control__1711_ u_dll_u_control__1711_/Y u_dll_u_control__1741_/A u_dll_u_control__2218_/Q
+ VPWR VGND sg13cmos5l_nor2b_1
Xu_dll_u_control_rebuffer129 u_dll_u_control__1464_/A2 u_dll_u_control__1418_/A VPWR
+ VGND sg13cmos5l_buf_1
Xu_dll_u_control__1573_ u_dll_u_control__1596_/A u_dll_u_control__1628_/A VPWR VGND
+ sg13cmos5l_inv_1
XFILLER_37_361 VPWR VGND sg13cmos5l_fill_1
XFILLER_44_49 VPWR VGND sg13cmos5l_fill_1
Xu_dll_u_control__2125_ u_dll_u_control__2125_/Y u_dll_u_control__2125_/A VPWR VGND
+ sg13cmos5l_inv_1
Xu_dll_u_control__2056_ u_dll_u_control__2056_/Y u_dll_u_control__2056_/A VPWR VGND
+ sg13cmos5l_inv_1
Xu_dll_u_control__1909_ u_dll_u_control__1910_/B u_dll_u_control__1909_/A u_dll_u_control__1909_/B
+ VPWR VGND sg13cmos5l_nand2_1
XFILLER_43_386 VPWR VGND sg13cmos5l_decap_8
XFILLER_7_210 VPWR VGND sg13cmos5l_decap_8
Xu_dll_u_ring_dstage\[1\].id_core_long_gate_u_nand u_dll_u_ring_dstage\[1\].id_core_long_gate_u_nand/Y
+ u_dll_u_ring_dstage\[1\].id_core_long_gate_u_nand/A u_dll_u_ring_dstage\[1\].id_core_long_gate_u_nand/B
+ VPWR VGND sg13cmos5l_nand2_2
XFILLER_38_125 VPWR VGND sg13cmos5l_fill_1
Xu_dll_u_ring_dstage\[0\].id_core_delayinv1_u_inv u_dll_u_ring_dstage\[0\].id_core_delayinv1_u_inv/Y
+ u_dll_u_ring_dstage\[0\].id_core_delayinv1_u_inv/A VPWR VGND sg13cmos5l_inv_2
XFILLER_22_4 VPWR VGND sg13cmos5l_fill_2
Xu_dll_u_ring_dstage\[7\].id_core_trim_reset_inv_u_inv u_dll_u_ring_dstage\[7\].id_core_trim_reset_inv_u_inv/Y
+ u_dll_u_ring_trim_reset_buffers\[2\].u_buffer_u_buf/X VPWR VGND sg13cmos5l_inv_2
Xu_dll__33_ u_dll__33_/Y u_dll__36_/A VPWR VGND sg13cmos5l_inv_1
Xu_dll_u_control__1625_ u_dll_u_control__1643_/A u_dll_u_control__1625_/A u_dll_u_control__1625_/B
+ VPWR VGND sg13cmos5l_xnor2_1
XFILLER_39_49 VPWR VGND sg13cmos5l_decap_4
XFILLER_29_136 VPWR VGND sg13cmos5l_fill_1
Xu_dll_u_control__1556_ u_dll_u_control__1560_/C u_dll_u_control__2137_/Q u_dll_u_control__2136_/Q
+ u_dll_u_control__2133_/Q u_dll_u_control__1556_/D VPWR VGND sg13cmos5l_nor4_1
XFILLER_17_309 VPWR VGND sg13cmos5l_decap_4
Xu_dll_u_control__1487_ u_dll_u_control__2160_/D u_dll_u_control__1487_/A u_dll_u_control__1487_/B
+ u_dll_u_control__1487_/C VPWR VGND sg13cmos5l_nor3_1
XFILLER_40_356 VPWR VGND sg13cmos5l_decap_8
Xu_dll_u_control__2039_ u_dll_u_control__2039_/Y u_dll_u_control__2056_/A VPWR VGND
+ sg13cmos5l_inv_1
Xu_dll_u_control__2108_ u_dll_u_control__2108_/Y u_dll_u_control__2118_/A VPWR VGND
+ sg13cmos5l_inv_1
XFILLER_4_246 VPWR VGND sg13cmos5l_decap_8
Xu_dll_u_ring_dstage\[4\].id_core_trim_sync\[0\].applied_u_ff u_dll_u_ring_dstage\[4\].id_core_delaymux1_u_a1/B
+ u_dll_u_ring_dstage\[4\].id_core_delayinv1_u_inv/Y u_dll_u_ring_dstage\[4\].id_core_trim_sync\[0\].meta_u_ff/Q
+ u_dll_u_ring_dstage\[4\].id_core_trim_reset_inv_u_inv/Y VPWR VGND sg13cmos5l_dfrbpq_1
XFILLER_43_172 VPWR VGND sg13cmos5l_decap_8
XFILLER_39_401 VPWR VGND sg13cmos5l_fill_2
Xu_dll_u_control__1410_ u_dll_u_control__1410_/Y u_dll_u_control__2181_/Q u_dll_u_control__1410_/B
+ VPWR VGND sg13cmos5l_nand2_1
Xu_dll_u_control__1272_ u_dll_u_control__2268_/D u_dll_u_control__1854_/A u_dll_u_control__1271_/Y
+ u_dll_u_control__2260_/D VPWR VGND sg13cmos5l_a21o_1
Xu_dll_u_control__1341_ u_dll_u_control__2204_/D u_dll_u_control__1345_/A u_dll_u_control__1341_/B
+ u_dll_u_control__1341_/C VPWR VGND sg13cmos5l_nor3_1
XFILLER_22_345 VPWR VGND sg13cmos5l_decap_8
Xu_dll_u_control__1539_ u_dll_u_control__1539_/Y u_dll_u_control__2224_/Q u_dll_u_control__2225_/Q
+ u_dll_u_control__1541_/B VPWR VGND sg13cmos5l_a21oi_1
Xu_dll_u_control__1608_ u_dll_u_control__1610_/C u_dll_u_control__2155_/Q u_dll_u_control__2154_/Q
+ u_dll_u_control__2153_/Q VPWR VGND sg13cmos5l_nor3_1
XFILLER_13_301 VPWR VGND sg13cmos5l_fill_1
Xu_dll_u_div1__084_ u_dll_u_div1__087_/B u_dll_u_div1__103_/Q u_dll_u_div1__104_/Q
+ u_dll_u_div1__084_/C VPWR VGND sg13cmos5l_nand3_1
XFILLER_31_197 VPWR VGND sg13cmos5l_fill_1
XFILLER_31_142 VPWR VGND sg13cmos5l_fill_1
Xu_dll_u_control__1890_ u_dll_u_control__2299_/D u_dll_u_control__1898_/A u_dll_u_control__2293_/Q
+ VPWR VGND sg13cmos5l_and2_1
XFILLER_39_275 VPWR VGND sg13cmos5l_fill_1
XFILLER_39_231 VPWR VGND sg13cmos5l_decap_8
Xu_dll_u_control__1186_ u_dll_u_control__1243_/A u_dll_u_control__1189_/B u_dll_u_control__1185_/Y
+ VPWR VGND sg13cmos5l_nor2b_1
Xu_dll_u_control__1324_ u_dll_u_control__1324_/Y u_dll_u_control__2207_/Q u_dll_u_control__1382_/A
+ u_dll_u_control__1392_/B VPWR VGND sg13cmos5l_nand3_1
Xu_dll_u_ring_dstage\[11\].id_core_delayinv1_u_inv u_dll_u_ring_dstage\[11\].id_core_delayinv1_u_inv/Y
+ u_dll_u_ring_dstage\[11\].id_core_delayinv1_u_inv/A VPWR VGND sg13cmos5l_inv_2
Xu_dll_u_ring_iss_core_delayint0_u_inv u_dll_u_ring_iss_core_delaymux1_u_a0/A u_dll_u_ring_iss_core_delayinv1_u_inv/Y
+ VPWR VGND sg13cmos5l_inv_1
Xu_dll_u_control__1255_ u_dll_u_control__2265_/D u_dll_u_control__1256_/B VPWR VGND
+ sg13cmos5l_inv_1
XFILLER_45_278 VPWR VGND sg13cmos5l_decap_4
XFILLER_42_82 VPWR VGND sg13cmos5l_fill_1
XFILLER_3_21 VPWR VGND sg13cmos5l_fill_2
Xu_dll_u_ring_dstage\[3\].id_core_delaymux1_u_sel u_dll_u_ring_dstage\[3\].id_core_delaymux1_u_a0/B
+ u_dll_u_ring_dstage\[3\].id_core_delaymux1_u_a1/B VPWR VGND sg13cmos5l_inv_1
Xu_dll_u_div1__067_ u_dll_u_div1__071_/A u_dll_u_div1__070_/A u_dll_u_div1__070_/B
+ u_dll_u_div1__064_/Y u_dll_u_div1__066_/Y VPWR VGND sg13cmos5l_a22oi_1
XFILLER_36_234 VPWR VGND sg13cmos5l_fill_1
Xclkbuf_3_2_0_u_dll\_controller_ring_clk clkbuf_3_2_0_u_dll\_controller_ring_clk/X
+ clkbuf_3_3_0_u_dll\_controller_ring_clk/A VPWR VGND sg13cmos5l_buf_8
Xu_dll_u_control__1942_ u_dll_u_control__1942_/Y u_dll_u_control__2077_/A VPWR VGND
+ sg13cmos5l_inv_1
Xu_dll_u_control__1873_ u_dll_u_control__2274_/D u_dll_u_control__1116_/Y u_dll_u_control__1117_/X
+ u_dll_u_control__1872_/Y VPWR VGND sg13cmos5l_a21oi_1
Xu_dll_u_control__1169_ u_dll_u_control__1169_/Y u_dll_u_control__1161_/Y u_dll_u_control__1164_/Y
+ u_dll_u_control__1168_/Y VPWR VGND sg13cmos5l_o21ai_1
Xu_dll_u_control__1307_ u_dll_u_control__1310_/B u_dll_u_control__2148_/Q u_dll_u_control__1300_/A
+ u_dll_u_control__1303_/Y VPWR VGND sg13cmos5l_o21ai_1
XFILLER_10_112 VPWR VGND sg13cmos5l_fill_2
Xu_dll_u_control__2287_ u_dll_u_control__2287_/Q u_dll_u_control__2298_/CLK u_dll_u_control__2287_/D
+ u_dll_u_control__1947_/Y VPWR VGND sg13cmos5l_dfrbpq_1
Xu_dll_u_control__1238_ u_dll_u_control__1285_/A u_dll_u_control__1238_/A u_dll_u_control__1860_/A
+ VPWR VGND sg13cmos5l_or2_1
Xu_dll_u_div0__085_ u_dll_u_div0__086_/B u_dll_u_div0__085_/A u_dll_u_div0__085_/B
+ VPWR VGND sg13cmos5l_xnor2_1
XFILLER_5_2 VPWR VGND sg13cmos5l_fill_1
XFILLER_18_212 VPWR VGND sg13cmos5l_decap_4
Xu_dll_u_control__2210_ u_dll_u_control__2210_/Q u_dll_u_control__2214_/CLK u_dll_u_control__2210_/D
+ u_dll_u_control__2067_/Y VPWR VGND sg13cmos5l_dfrbpq_1
Xu_dll_u_control__2141_ u_dll_u_control__2141_/Q u_dll_u_control__2279_/CLK u_dll_u_control__2141_/D
+ u_dll_u_control__1998_/Y VPWR VGND sg13cmos5l_dfrbpq_1
XFILLER_33_29 VPWR VGND sg13cmos5l_fill_2
Xu_dll_u_control__2072_ u_dll_u_control__2072_/Y u_dll_u_control__2125_/A VPWR VGND
+ sg13cmos5l_inv_1
Xu_dll_u_control__1925_ u_dll_u_control__2150_/D u_dll_u_control__1925_/A VPWR VGND
+ sg13cmos5l_buf_1
Xu_dll_u_control_fanout19 u_dll_u_control__1501_/B u_dll_u_control__1466_/Y VPWR VGND
+ sg13cmos5l_buf_1
Xu_dll_u_control__1787_ u_dll_u_control__2243_/D u_dll_u_control__1783_/Y u_dll_u_control__1785_/Y
+ u_dll_u_control__1786_/Y VPWR VGND sg13cmos5l_a21oi_1
Xu_dll_u_control__1856_ u_dll_u_control__1860_/B u_dll_u_control__1686_/C u_dll_u_control__1849_/B
+ u_dll_u_control__1245_/X VPWR VGND sg13cmos5l_o21ai_1
XFILLER_7_403 VPWR VGND sg13cmos5l_fill_1
Xu_dll_u_div0__068_ u_dll_u_div0__069_/C u_dll_u_div0__062_/A u_dll_u_div0__062_/B
+ u_dll_u_div0__050_/Y VPWR VGND sg13cmos5l_a21oi_1
XFILLER_38_307 VPWR VGND sg13cmos5l_fill_2
Xu_dll_u_ring_dstage\[9\].id_core_delayint0_u_inv u_dll_u_ring_dstage\[9\].id_core_delaymux1_u_a0/A
+ u_dll_u_ring_dstage\[9\].id_core_delayinv1_u_inv/Y VPWR VGND sg13cmos5l_inv_1
XFILLER_9_42 VPWR VGND sg13cmos5l_fill_2
Xu_dll_u_ring_iss_core_fast_decode_u_nor u_dll_u_ring_iss_core_reset_gate_u_aoi/A2
+ u_dll_u_ring_iss_core_delaymux1_u_a1/B u_dll_u_ring_iss_core_long_gate_u_nand/B
+ VPWR VGND sg13cmos5l_nor2_2
Xu_dll_u_ring_dstage\[3\].id_core_reset_inv_u_inv u_dll_u_ring_dstage\[3\].id_core_reset_inv_u_inv/Y
+ u_dll_u_ring_dstage\[3\].id_const0_u_lo/L_LO VPWR VGND sg13cmos5l_inv_1
Xu_dll_u_control__1572_ u_dll_u_control__1628_/A u_dll_u_control__2140_/Q u_dll_u_control__1629_/B
+ VPWR VGND sg13cmos5l_xnor2_1
Xu_dll_u_control__1641_ u_dll_u_control__1642_/D u_dll_u_control__1641_/A u_dll_u_control__1665_/B
+ VPWR VGND sg13cmos5l_nor2b_1
XFILLER_43_0 VPWR VGND sg13cmos5l_fill_1
Xu_dll_u_control__1710_ u_dll_u_control__1710_/Y u_dll_u_control__2218_/Q u_dll_u_control__2220_/Q
+ VPWR VGND sg13cmos5l_xnor2_1
Xu_dll_u_control__2124_ u_dll_u_control__2124_/Y u_dll_u_control__2124_/A VPWR VGND
+ sg13cmos5l_inv_1
Xu_dll_u_control__2055_ u_dll_u_control__2055_/Y u_dll_u_control__2056_/A VPWR VGND
+ sg13cmos5l_inv_1
Xu_dll_u_control__1908_ u_dll_u_control__1909_/B u_dll_u_control__2306_/Q u_dll_u_control__2307_/Q
+ u_dll_u_control__2308_/Q VPWR VGND sg13cmos5l_nand3_1
Xu_dll_u_control__1839_ u_dll_u_control__1848_/A u_dll_u_control__1863_/A u_dll_u_control__1829_/X
+ u_dll_u_control__1876_/A VPWR VGND sg13cmos5l_a21oi_1
XFILLER_18_62 VPWR VGND sg13cmos5l_fill_2
XFILLER_43_354 VPWR VGND sg13cmos5l_fill_2
Xu_dll_u_ring_u_output_inv0_u_inv u_dll_u_ring_u_output_inv1_u_inv/A u_dll_u_ring_u_output_inv0_u_inv/A
+ VPWR VGND sg13cmos5l_inv_2
XFILLER_11_240 VPWR VGND sg13cmos5l_fill_2
XFILLER_11_284 VPWR VGND sg13cmos5l_decap_8
Xclkbuf_5_5__f_u_dll\_controller_ref_clk clkload1/A clkbuf_4_2_0_u_dll\_controller_ref_clk/X
+ VPWR VGND sg13cmos5l_buf_8
Xu_dll__32_ u_dll__32_/Y u_dll__36_/A VPWR VGND sg13cmos5l_inv_1
Xu_dll_u_control__1555_ u_dll_u_control__1560_/B u_dll_u_control__2144_/Q u_dll_u_control__2139_/Q
+ u_dll_u_control__2138_/Q u_dll_u_control__2135_/Q VPWR VGND sg13cmos5l_nor4_1
Xu_dll_u_control__1624_ u_dll_u_control__1647_/B u_dll_u_control__1624_/A u_dll_u_control__1624_/B
+ VPWR VGND sg13cmos5l_xnor2_1
Xu_dll_u_ring_dstage\[5\].id_core_reset_gate_u_aoi u_dll_u_ring_dstage\[5\].id_core_reset_gate_u_aoi/Y
+ u_dll_u_ring_dstage\[4\].id_core_reset_gate_u_aoi/Y u_dll_u_ring_dstage\[5\].id_core_reset_gate_u_aoi/A2
+ u_dll_u_ring_dstage\[5\].id_core_reset_gate_u_aoi/B1 VPWR VGND sg13cmos5l_a21oi_2
Xu_dll_u_control__1486_ u_dll_u_control__1487_/C u_dll_u_control__2160_/Q u_dll_u_control__1501_/B
+ VPWR VGND sg13cmos5l_nor2_1
Xu_dll_u_control__2107_ u_dll_u_control__2107_/Y u_dll_u_control__2119_/A VPWR VGND
+ sg13cmos5l_inv_1
Xu_dll_u_control__2038_ u_dll_u_control__2038_/Y u_dll_u_control__2056_/A VPWR VGND
+ sg13cmos5l_inv_1
XFILLER_48_402 VPWR VGND sg13cmos5l_fill_2
XFILLER_4_225 VPWR VGND sg13cmos5l_decap_8
Xu_dll_u_ring_dstage\[2\].id_core_delaybuf1_u_buf u_dll_u_ring_dstage\[2\].id_core_delayinv1_u_inv/A
+ u_dll_u_ring_dstage\[2\].id_core_delaymux1_u_a1/A VPWR VGND sg13cmos5l_buf_1
XFILLER_31_335 VPWR VGND sg13cmos5l_fill_2
XFILLER_31_302 VPWR VGND sg13cmos5l_fill_1
XFILLER_16_398 VPWR VGND sg13cmos5l_decap_4
XFILLER_34_184 VPWR VGND sg13cmos5l_fill_2
Xu_dll_u_control__1271_ u_dll_u_control__1271_/Y u_dll_u_control__1851_/A u_dll_u_control__1851_/C
+ u_dll_u_control__1846_/B u_dll_u_control__1849_/B VPWR VGND sg13cmos5l_nor4_1
Xu_dll_u_control__1340_ u_dll_u_control__1341_/C u_dll_u_control__2204_/Q u_dll_u_control__1924_/A1
+ VPWR VGND sg13cmos5l_nor2b_1
XFILLER_19_170 VPWR VGND sg13cmos5l_fill_1
XFILLER_22_324 VPWR VGND sg13cmos5l_decap_8
XFILLER_25_19 VPWR VGND sg13cmos5l_decap_4
Xu_dll_u_control__1538_ u_dll_u_control__1538_/Y u_dll_u_control__2321_/Q u_dll_u_control__1605_/C
+ VPWR VGND sg13cmos5l_nand2_1
Xu_dll_u_control__1607_ u_dll_u_control__1610_/B u_dll_u_control__2163_/Q u_dll_u_control__2162_/Q
+ u_dll_u_control__2161_/Q u_dll_u_control__2160_/Q VPWR VGND sg13cmos5l_nor4_1
XFILLER_40_132 VPWR VGND sg13cmos5l_decap_8
Xu_dll_u_control__1469_ u_dll_u_control__1469_/Y u_dll_u_control__1469_/A u_dll_u_control__1469_/B
+ VPWR VGND sg13cmos5l_nor2_1
XFILLER_40_187 VPWR VGND sg13cmos5l_fill_2
XFILLER_48_243 VPWR VGND sg13cmos5l_fill_1
Xu_dll_u_div1__083_ u_dll_u_div1__103_/D u_dll_u_div1__088_/A u_dll_u_div1__083_/B
+ VPWR VGND sg13cmos5l_nor2_1
XFILLER_31_187 VPWR VGND sg13cmos5l_fill_2
XFILLER_8_383 VPWR VGND sg13cmos5l_fill_2
Xu_dll_u_control__1323_ u_dll_u_control__1923_/C u_dll_u_control__1392_/B u_dll_u_control__2196_/Q
+ u_dll_u_control__2201_/Q u_dll_u_control__1323_/D VPWR VGND sg13cmos5l_nand4_1
Xu_dll_u_control__1185_ u_dll_u_control__1185_/Y u_dll_u_control__2281_/Q u_dll_u_control__1183_/A
+ u_dll_u_control__2282_/Q VPWR VGND sg13cmos5l_o21ai_1
Xclkbuf_5_16__f_u_dll\_controller_ref_clk u_dll_u_control__2268_/CLK clkbuf_4_8_0_u_dll\_controller_ref_clk/X
+ VPWR VGND sg13cmos5l_buf_8
Xu_dll_u_control__1254_ u_dll_u_control__1256_/B u_dll_u_control__1851_/B u_dll_u_control__1841_/C
+ u_dll_u_control__1834_/C VPWR VGND sg13cmos5l_nand3_1
XFILLER_10_338 VPWR VGND sg13cmos5l_fill_1
XFILLER_26_73 VPWR VGND sg13cmos5l_decap_4
XFILLER_5_397 VPWR VGND sg13cmos5l_decap_4
Xu_dll_u_div1__066_ u_dll_u_div1__066_/Y u_dll_u_div1__102_/Q u_dll_u_div1__063_/Y
+ u_dll_u_div1__065_/Y u_dll_u_div1__054_/Y VPWR VGND sg13cmos5l_a22oi_1
XFILLER_3_55 VPWR VGND sg13cmos5l_decap_4
Xu_dll_u_control__1941_ u_dll_u_control__1941_/Y u_dll_u_control__2119_/A VPWR VGND
+ sg13cmos5l_inv_1
Xu_dll_u_control__1872_ u_dll_u_control__1872_/Y u_dll_u_control__1116_/Y u_dll_u_control__1117_/X
+ u_dll_u_control__1878_/B VPWR VGND sg13cmos5l_o21ai_1
Xu_dll_u_control__2286_ u_dll_u_control__2286_/Q u_dll_u_control__2286_/CLK u_dll_u_control__2286_/D
+ u_dll_u_control__1946_/Y VPWR VGND sg13cmos5l_dfrbpq_1
Xu_dll_u_control__1306_ u_dll_u_control__1310_/A u_dll_u_control__1083_/Y u_dll_u_control__1925_/A
+ u_dll_u_control__1304_/Y VPWR VGND sg13cmos5l_o21ai_1
Xu_dll_u_control__1168_ u_dll_u_control__1168_/Y u_dll_u_control__2284_/Q u_dll_u_control__1163_/X
+ u_dll_u_control__1171_/B u_dll_u_control__1227_/A VPWR VGND sg13cmos5l_a22oi_1
Xu_dll_u_control__1099_ u_dll_u_control__1789_/B u_dll_u_control__1099_/A VPWR VGND
+ sg13cmos5l_inv_1
Xu_dll_u_control__1237_ u_dll_u_control__1860_/A u_dll_u_control__1867_/A u_dll_u_control__1851_/B
+ u_dll_u_control__1841_/C VPWR VGND sg13cmos5l_nand3_1
Xu_dll_u_div0__084_ u_dll_u_div0__087_/B u_dll_u_div0__103_/Q u_dll_u_div0__104_/Q
+ u_dll_u_div0__084_/C VPWR VGND sg13cmos5l_nand3_1
XFILLER_12_31 VPWR VGND sg13cmos5l_decap_4
Xu_dll_u_control__2140_ u_dll_u_control__2140_/Q u_dll_u_control__2279_/CLK u_dll_u_control__2140_/D
+ u_dll_u_control__1997_/Y VPWR VGND sg13cmos5l_dfrbpq_1
Xu_dll_u_div1__049_ u_dll_u_div1__112_/D uio_in[3] VPWR VGND sg13cmos5l_inv_1
Xu_dll_u_control__2071_ u_dll_u_control__2071_/Y u_dll_u_control__2125_/A VPWR VGND
+ sg13cmos5l_inv_1
Xu_dll_u_control__1855_ u_dll_u_control__2250_/D u_dll_u_control__1855_/A u_dll_u_control__1855_/B
+ VPWR VGND sg13cmos5l_nor2_1
Xu_dll_u_control__1924_ u_dll_u_control__2315_/D u_dll_u_control__1924_/A1 u_dll_u_control__1398_/B
+ u_dll_u_control__1923_/Y VPWR VGND sg13cmos5l_a21o_1
Xu_dll_u_control__1786_ u_dll_u_control__1786_/Y u_dll_u_control__1783_/Y u_dll_u_control__1785_/Y
+ u_dll_u_control__1679_/A VPWR VGND sg13cmos5l_o21ai_1
Xu_dll_u_ring_dstage\[8\].id_core_trim_reset_inv_u_inv u_dll_u_ring_dstage\[8\].id_core_trim_reset_inv_u_inv/Y
+ u_dll_u_ring_trim_reset_buffers\[2\].u_buffer_u_buf/X VPWR VGND sg13cmos5l_inv_2
Xu_dll_u_control__2269_ u_dll_u_control__2269_/Q clkload1/A u_dll_u_control__2269_/D
+ u_dll_u_control__2126_/Y VPWR VGND sg13cmos5l_dfrbpq_1
Xu_dll_u_div0_u_bypass_mux_u_sel u_dll_u_div0_u_bypass_mux_u_a0/B u_dll_u_div0__061_/Y
+ VPWR VGND sg13cmos5l_inv_1
Xu_dll_u_div0__067_ u_dll_u_div0__071_/A u_dll_u_div0__070_/A u_dll_u_div0__070_/B
+ u_dll_u_div0__064_/Y u_dll_u_div0__066_/Y VPWR VGND sg13cmos5l_a22oi_1
XFILLER_3_0 VPWR VGND sg13cmos5l_decap_8
XFILLER_2_153 VPWR VGND sg13cmos5l_fill_1
XFILLER_46_385 VPWR VGND sg13cmos5l_decap_8
Xu_dll_u_control__1571_ u_dll_u_control__1571_/Y u_dll_u_control__1571_/A u_dll_u_control__1618_/B
+ VPWR VGND sg13cmos5l_nand2_1
Xu_dll_u_control__1640_ u_dll_u_control__1641_/A u_dll_u_control__1667_/B u_dll_u_control__1669_/B
+ u_dll_u_control__1671_/B u_dll_u_control__1673_/B VPWR VGND sg13cmos5l_nand4_1
XFILLER_36_0 VPWR VGND sg13cmos5l_decap_8
XFILLER_29_308 VPWR VGND sg13cmos5l_fill_1
Xu_dll_u_ring_trim_reset_buffers\[2\].u_buffer_u_buf u_dll_u_ring_trim_reset_buffers\[2\].u_buffer_u_buf/X
+ u_dll_u_ring_reset_buffer_u_buf/X VPWR VGND sg13cmos5l_buf_4
XFILLER_49_190 VPWR VGND sg13cmos5l_decap_8
Xu_dll_u_control__2123_ u_dll_u_control__2123_/Y u_dll_u_control__2124_/A VPWR VGND
+ sg13cmos5l_inv_1
Xu_dll_u_control__2054_ u_dll_u_control__2054_/Y u_dll_u_control__2064_/A VPWR VGND
+ sg13cmos5l_inv_1
Xu_dll_u_control__1838_ u_dll_u_control__1858_/B u_dll_u_control__1851_/B u_dll_u_control__1838_/B
+ VPWR VGND sg13cmos5l_nand2_1
Xu_dll_u_control__1907_ u_dll_u_control__1910_/A u_dll_u_control__2306_/Q u_dll_u_control__2307_/Q
+ u_dll_u_control__2308_/Q VPWR VGND sg13cmos5l_a21oi_1
Xu_dll_u_enable_buffer_u_buf u_dll_fanout100/A ena VPWR VGND sg13cmos5l_buf_4
Xu_dll_u_control__1769_ u_dll_u_control__1776_/B u_dll_u_control__1768_/Y u_dll_u_control__1783_/A
+ VPWR VGND sg13cmos5l_nand2b_1
Xu_dll_u_div1_u_parity_mux_u_a0 u_dll_u_div1_u_parity_mux_u_a0/Y u_dll_u_div1__100_/D
+ u_dll_u_div1_u_parity_mux_u_a0/B VPWR VGND sg13cmos5l_nand2_2
XFILLER_34_51 VPWR VGND sg13cmos5l_fill_1
Xu_dll__31_ u_dll__31_/Y u_dll__36_/A VPWR VGND sg13cmos5l_inv_1
Xu_dll_u_control__1554_ u_dll_u_control__1556_/D u_dll_u_control__2134_/Q u_dll_u_control__2132_/Q
+ VPWR VGND sg13cmos5l_or2_1
Xu_dll_u_control__1623_ u_dll_u_control__1649_/B u_dll_u_control__1623_/A u_dll_u_control__1623_/B
+ VPWR VGND sg13cmos5l_xor2_1
XFILLER_29_149 VPWR VGND sg13cmos5l_fill_1
Xu_dll_u_control__1485_ u_dll_u_control__1487_/B u_dll_u_control__2188_/Q u_dll_u_control__1485_/B
+ VPWR VGND sg13cmos5l_nor2_1
XFILLER_40_325 VPWR VGND sg13cmos5l_fill_1
Xu_dll_u_ring_dstage\[4\].id_core_delaymux1_u_a0 u_dll_u_ring_dstage\[4\].id_core_delaymux1_u_a0/Y
+ u_dll_u_ring_dstage\[4\].id_core_delaymux1_u_a0/A u_dll_u_ring_dstage\[4\].id_core_delaymux1_u_a0/B
+ VPWR VGND sg13cmos5l_nand2_2
Xu_dll_u_control__2106_ u_dll_u_control__2106_/Y u_dll_u_control__2118_/A VPWR VGND
+ sg13cmos5l_inv_1
Xu_dll_u_control__2037_ u_dll_u_control__2037_/Y u_dll_u_control__2050_/A VPWR VGND
+ sg13cmos5l_inv_1
XFILLER_20_53 VPWR VGND sg13cmos5l_fill_2
XFILLER_45_83 VPWR VGND sg13cmos5l_decap_4
XFILLER_43_152 VPWR VGND sg13cmos5l_fill_2
XFILLER_35_108 VPWR VGND sg13cmos5l_decap_4
Xu_dll_u_ring_dstage\[6\].id_core_long_gate_u_nand u_dll_u_ring_dstage\[6\].id_core_long_gate_u_nand/Y
+ u_dll_u_ring_dstage\[6\].id_core_long_gate_u_nand/A u_dll_u_ring_dstage\[6\].id_core_long_gate_u_nand/B
+ VPWR VGND sg13cmos5l_nand2_2
Xu_dll_u_ring_iss_core_delaymux1_u_a0 u_dll_u_ring_iss_core_delaymux1_u_a0/Y u_dll_u_ring_iss_core_delaymux1_u_a0/A
+ u_dll_u_ring_iss_core_delaymux1_u_a0/B VPWR VGND sg13cmos5l_nand2_2
XFILLER_39_403 VPWR VGND sg13cmos5l_fill_1
Xclkbuf_4_4__f_u_dll\_controller_ring_clk u_dll_u_control__2199_/CLK clkbuf_3_2_0_u_dll\_controller_ring_clk/X
+ VPWR VGND sg13cmos5l_buf_8
XFILLER_26_108 VPWR VGND sg13cmos5l_fill_1
Xu_dll_u_control__1270_ u_dll_u_control__1863_/A u_dll_u_control__1851_/C u_dll_u_control__1846_/B
+ VPWR VGND sg13cmos5l_nor2_1
XFILLER_22_303 VPWR VGND sg13cmos5l_decap_8
XFILLER_30_380 VPWR VGND sg13cmos5l_fill_1
XFILLER_1_229 VPWR VGND sg13cmos5l_fill_1
Xu_dll_u_control__1606_ u_dll_u_control__1610_/A u_dll_u_control__2165_/Q u_dll_u_control__2164_/Q
+ VPWR VGND sg13cmos5l_nor2_1
Xu_dll_u_control__1537_ u_dll_u_control__1537_/Y u_dll_u_control__2322_/Q u_dll_u_control__1537_/B
+ VPWR VGND sg13cmos5l_nor2_1
Xu_dll_u_control__1468_ u_dll_u_control__1472_/A u_dll_u_control__2193_/Q u_dll_u_control__1506_/B
+ VPWR VGND sg13cmos5l_nor2_1
XFILLER_40_177 VPWR VGND sg13cmos5l_decap_4
XFILLER_40_122 VPWR VGND sg13cmos5l_fill_1
XFILLER_13_325 VPWR VGND sg13cmos5l_fill_2
Xu_dll_u_control__1399_ u_dll_u_control__2187_/D u_dll_u_control__1361_/B u_dll_u_control__1386_/C
+ u_dll_u_control__1398_/Y VPWR VGND sg13cmos5l_o21ai_1
Xu_dll_u_div1__082_ u_dll_u_div1__083_/B u_dll_u_div1__103_/Q u_dll_u_div1__084_/C
+ VPWR VGND sg13cmos5l_xnor2_1
XFILLER_0_251 VPWR VGND sg13cmos5l_decap_4
XFILLER_31_166 VPWR VGND sg13cmos5l_decap_8
XFILLER_39_200 VPWR VGND sg13cmos5l_fill_1
.ends
